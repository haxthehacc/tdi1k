// Design: tdi1k/column_isource_tb
simulator lang=spectre
global 0
include "/home/install/SCL180/SCLPDK_V3.0_KIT/scl180/pdk/cdns/sclpdk_v3/HOTCODE/models/ts18scl/v2.0/hspice/header.lib"

// tdi1k/column_isource/schematic
subckt column_isource GND IOUT VDD
    POUT_0 (IOUT net1 VDD VDD) p18 w=4.0 l=1.0 m=(1)*(1)
    PREF (net1 net1 VDD VDD) p18 w=4.0 l=1.0 m=(1)*(1)
    I0 (net1 GND) isource dc=1u type=dc
ends column_isource

// tdi1k/column_isource_tb/schematic
I0 (0 net2 net1) column_isource
V1 (net2 0) vsource dc=900.0m type=dc
V0 (net1 0) vsource dc=1.8 type=dc
simulatorOptions options temp=27 scale=1e-06
dcOp dc
dc dc dev=V0 param=dc start=1.6 stop=1.9 step=0.01
saveOptions options subcktprobelvl=2
