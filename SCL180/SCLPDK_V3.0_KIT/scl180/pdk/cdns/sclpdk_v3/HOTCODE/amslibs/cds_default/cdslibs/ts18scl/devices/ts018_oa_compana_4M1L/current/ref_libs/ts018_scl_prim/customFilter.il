procedure( ts018_scl_prim_AxlCustomDeviceFilter( inst simulator )
	prog((paramList returnList)

		case( inst~>cellName
			( "ch53t"
				returnList = cons( list( "m" inst~>m ) returnList)
				returnList = cons( list( "w" inst~>w ) returnList)
				returnList = cons( list( "l" inst~>l ) returnList)
				returnList = cons( list( "fingersCap" inst~>fingersCap ) returnList)
				returnList = cons( list( "connectDiff" inst~>connectDiff ) returnList)
			)
			( "cm32t"
				when( evalstring( "inst->userParams != \"Capacitance\"" )
					returnList = cons( list( "c" inst~>c ) returnList)
				)
				when( evalstring( "inst->userParams != \"Length\"" )
					returnList = cons( list( "llayout" inst~>llayout ) returnList)
				)
				returnList = cons( list( "nf" inst~>nf ) returnList)
			)
			( "cm33t"
				when( evalstring( "inst->userParams != \"Capacitance\"" )
					returnList = cons( list( "c" inst~>c ) returnList)
				)
				when( evalstring( "inst->userParams != \"Length\"" )
					returnList = cons( list( "llayout" inst~>llayout ) returnList)
				)
				returnList = cons( list( "nf" inst~>nf ) returnList)
			)
			( "cmim_hc"
				when( evalstring( "inst->userParams != \"Capacitance\"" )
					returnList = cons( list( "c" inst~>c ) returnList)
				)
				when( evalstring( "inst->userParams != \"Length\"" )
					returnList = cons( list( "l" inst~>l ) returnList)
				)
				when( evalstring( "inst->userParams != \"Width\"" )
					returnList = cons( list( "w" inst~>w ) returnList)
				)
				returnList = cons( list( "m" inst~>m ) returnList)
				returnList = cons( list( "remPinRout" inst~>remPinRout ) returnList)
			)
			( "cmim_sq"
				when( evalstring( "inst->userParams != \"Capacitance\"" )
					returnList = cons( list( "c" inst~>c ) returnList)
				)
				when( evalstring( "inst->userParams != \"Length\"" )
					returnList = cons( list( "l" inst~>l ) returnList)
				)
				when( evalstring( "inst->userParams != \"Width\"" )
					returnList = cons( list( "w" inst~>w ) returnList)
				)
				returnList = cons( list( "m" inst~>m ) returnList)
				returnList = cons( list( "remPinRout" inst~>remPinRout ) returnList)
			)
			( "cmim_stk"
				when( evalstring( "inst->userParams != \"Capacitance\"" )
					returnList = cons( list( "c" inst~>c ) returnList)
				)
				when( evalstring( "inst->userParams != \"Length\"" )
					returnList = cons( list( "l" inst~>l ) returnList)
				)
				when( evalstring( "inst->userParams != \"Width\"" )
					returnList = cons( list( "w" inst~>w ) returnList)
				)
				returnList = cons( list( "m" inst~>m ) returnList)
			)
			( "cmim_uhd"
				when( evalstring( "inst->userParams != \"Capacitance\"" )
					returnList = cons( list( "c" inst~>c ) returnList)
				)
				when( evalstring( "inst->userParams != \"Length\"" )
					returnList = cons( list( "l" inst~>l ) returnList)
				)
				when( evalstring( "inst->userParams != \"Width\"" )
					returnList = cons( list( "w" inst~>w ) returnList)
				)
				returnList = cons( list( "m" inst~>m ) returnList)
				returnList = cons( list( "q" inst~>q ) returnList)
			)
			( "cmim_uhdstk"
				when( evalstring( "inst->userParams != \"Capacitance\"" )
					returnList = cons( list( "c" inst~>c ) returnList)
				)
				when( evalstring( "inst->userParams != \"Length\"" )
					returnList = cons( list( "l" inst~>l ) returnList)
				)
				when( evalstring( "inst->userParams != \"Width\"" )
					returnList = cons( list( "w" inst~>w ) returnList)
				)
				returnList = cons( list( "m" inst~>m ) returnList)
				returnList = cons( list( "q" inst~>q ) returnList)
			)
			( "cnwnmos_thk2t"
				returnList = cons( list( "m" inst~>m ) returnList)
				returnList = cons( list( "w" inst~>w ) returnList)
				returnList = cons( list( "l" inst~>l ) returnList)
				returnList = cons( list( "fingersCap" inst~>fingersCap ) returnList)
				returnList = cons( list( "connectDiff" inst~>connectDiff ) returnList)
			)
			( "cnwnmos_thk3t"
				returnList = cons( list( "m" inst~>m ) returnList)
				returnList = cons( list( "w" inst~>w ) returnList)
				returnList = cons( list( "l" inst~>l ) returnList)
				returnList = cons( list( "fingersCap" inst~>fingersCap ) returnList)
				returnList = cons( list( "connectDiff" inst~>connectDiff ) returnList)
			)
			( "cnwnmos_thn2t"
				returnList = cons( list( "m" inst~>m ) returnList)
				returnList = cons( list( "w" inst~>w ) returnList)
				returnList = cons( list( "l" inst~>l ) returnList)
				returnList = cons( list( "fingersCap" inst~>fingersCap ) returnList)
				returnList = cons( list( "connectDiff" inst~>connectDiff ) returnList)
			)
			( "ddwnps18"
				when( evalstring( "inst->fixedLayout != \"Yes\" && inst->calcParam!=\"area\"" )
					returnList = cons( list( "area" inst~>area ) returnList)
				)
				when( evalstring( "inst->widthVisible == \"Yes\" && inst->calcParam!=\"width\"" )
					returnList = cons( list( "w" inst~>w ) returnList)
				)
				when( evalstring( "inst->fixedLayout != \"Yes\" && inst->calcParam!=\"length\"" )
					returnList = cons( list( "l" inst~>l ) returnList)
				)
				returnList = cons( list( "m" inst~>m ) returnList)
				returnList = cons( list( "perim" inst~>perim ) returnList)
				returnList = cons( list( "removeTap" inst~>removeTap ) returnList)
			)
			( "ddwnpw18"
				when( evalstring( "inst->fixedLayout != \"Yes\" && inst->calcParam!=\"area\"" )
					returnList = cons( list( "area" inst~>area ) returnList)
				)
				when( evalstring( "inst->widthVisible == \"Yes\" && inst->calcParam!=\"width\"" )
					returnList = cons( list( "w" inst~>w ) returnList)
				)
				when( evalstring( "inst->fixedLayout != \"Yes\" && inst->calcParam!=\"length\"" )
					returnList = cons( list( "l" inst~>l ) returnList)
				)
				returnList = cons( list( "m" inst~>m ) returnList)
				returnList = cons( list( "perim" inst~>perim ) returnList)
				returnList = cons( list( "removeTap" inst~>removeTap ) returnList)
			)
			( "dn50"
				when( evalstring( "inst->fixedLayout != \"Yes\" && inst->calcParam!=\"area\"" )
					returnList = cons( list( "area" inst~>area ) returnList)
				)
				when( evalstring( "inst->widthVisible == \"Yes\" && inst->calcParam!=\"width\"" )
					returnList = cons( list( "w" inst~>w ) returnList)
				)
				when( evalstring( "inst->fixedLayout != \"Yes\" && inst->calcParam!=\"length\"" )
					returnList = cons( list( "l" inst~>l ) returnList)
				)
				returnList = cons( list( "m" inst~>m ) returnList)
				returnList = cons( list( "perim" inst~>perim ) returnList)
				returnList = cons( list( "removeTap" inst~>removeTap ) returnList)
			)
			( "dp50"
				when( evalstring( "inst->fixedLayout != \"Yes\" && inst->calcParam!=\"area\"" )
					returnList = cons( list( "area" inst~>area ) returnList)
				)
				when( evalstring( "inst->widthVisible == \"Yes\" && inst->calcParam!=\"width\"" )
					returnList = cons( list( "w" inst~>w ) returnList)
				)
				when( evalstring( "inst->fixedLayout != \"Yes\" && inst->calcParam!=\"length\"" )
					returnList = cons( list( "l" inst~>l ) returnList)
				)
				returnList = cons( list( "m" inst~>m ) returnList)
				returnList = cons( list( "perim" inst~>perim ) returnList)
				returnList = cons( list( "removeTap" inst~>removeTap ) returnList)
			)
			( "epf"
				when( evalstring( "inst->isREditable" )
					returnList = cons( list( "r" inst~>r ) returnList)
				)
				returnList = cons( list( "is_status" inst~>is_status ) returnList)
				returnList = cons( list( "isREditable" inst~>isREditable ) returnList)
			)
			( "mr22t"
				when( evalstring( "inst->calculatedParam != \"Resistance\"" )
					returnList = cons( list( "r" inst~>r ) returnList)
				)
				when( evalstring( "inst->calculatedParam != \"Length\"" )
					returnList = cons( list( "segLength" inst~>segLength ) returnList)
				)
				when( evalstring( "inst->calculatedParam != \"Width\"" )
					returnList = cons( list( "w" inst~>w ) returnList)
				)
				returnList = cons( list( "segments" inst~>segments ) returnList)
				returnList = cons( list( "segConfig" inst~>segConfig ) returnList)
				returnList = cons( list( "sf" inst~>sf ) returnList)
				returnList = cons( list( "r3_flag" inst~>r3_flag ) returnList)
			)
			( "mr23t"
				when( evalstring( "inst->calculatedParam != \"Resistance\"" )
					returnList = cons( list( "r" inst~>r ) returnList)
				)
				when( evalstring( "inst->calculatedParam != \"Length\"" )
					returnList = cons( list( "segLength" inst~>segLength ) returnList)
				)
				when( evalstring( "inst->calculatedParam != \"Width\"" )
					returnList = cons( list( "w" inst~>w ) returnList)
				)
				returnList = cons( list( "segments" inst~>segments ) returnList)
				returnList = cons( list( "segConfig" inst~>segConfig ) returnList)
				returnList = cons( list( "sf" inst~>sf ) returnList)
				returnList = cons( list( "r3_flag" inst~>r3_flag ) returnList)
			)
			( "n18hvt"
				returnList = cons( list( "w" inst~>w ) returnList)
				returnList = cons( list( "l" inst~>l ) returnList)
				when( evalstring( "inst->applyThresh == nil" )
					returnList = cons( list( "nf" inst~>nf ) returnList)
				)
				returnList = cons( list( "m" inst~>m ) returnList)
				returnList = cons( list( "polyConnStyle" inst~>polyConnStyle ) returnList)
				returnList = cons( list( "mEndcapWidth" inst~>mEndcapWidth ) returnList)
				returnList = cons( list( "mPolyToDiffSpace" inst~>mPolyToDiffSpace ) returnList)
			)
			( "n18hvt_iso"
				returnList = cons( list( "w" inst~>w ) returnList)
				returnList = cons( list( "l" inst~>l ) returnList)
				when( evalstring( "inst->applyThresh == nil" )
					returnList = cons( list( "nf" inst~>nf ) returnList)
				)
				returnList = cons( list( "m" inst~>m ) returnList)
				returnList = cons( list( "polyConnStyle" inst~>polyConnStyle ) returnList)
				returnList = cons( list( "mEndcapWidth" inst~>mEndcapWidth ) returnList)
				returnList = cons( list( "mPolyToDiffSpace" inst~>mPolyToDiffSpace ) returnList)
			)
			( "n18lvt"
				returnList = cons( list( "w" inst~>w ) returnList)
				returnList = cons( list( "l" inst~>l ) returnList)
				when( evalstring( "inst->applyThresh == nil" )
					returnList = cons( list( "nf" inst~>nf ) returnList)
				)
				returnList = cons( list( "m" inst~>m ) returnList)
				returnList = cons( list( "polyConnStyle" inst~>polyConnStyle ) returnList)
				returnList = cons( list( "mEndcapWidth" inst~>mEndcapWidth ) returnList)
				returnList = cons( list( "mPolyToDiffSpace" inst~>mPolyToDiffSpace ) returnList)
			)
			( "n18lvt_iso"
				returnList = cons( list( "w" inst~>w ) returnList)
				returnList = cons( list( "l" inst~>l ) returnList)
				when( evalstring( "inst->applyThresh == nil" )
					returnList = cons( list( "nf" inst~>nf ) returnList)
				)
				returnList = cons( list( "m" inst~>m ) returnList)
				returnList = cons( list( "polyConnStyle" inst~>polyConnStyle ) returnList)
				returnList = cons( list( "mEndcapWidth" inst~>mEndcapWidth ) returnList)
				returnList = cons( list( "mPolyToDiffSpace" inst~>mPolyToDiffSpace ) returnList)
			)
			( "ndio_33"
				when( evalstring( "inst->fixedLayout != \"Yes\" && inst->calcParam!=\"area\"" )
					returnList = cons( list( "area" inst~>area ) returnList)
				)
				when( evalstring( "inst->widthVisible == \"Yes\" && inst->calcParam!=\"width\"" )
					returnList = cons( list( "w" inst~>w ) returnList)
				)
				when( evalstring( "inst->fixedLayout != \"Yes\" && inst->calcParam!=\"length\"" )
					returnList = cons( list( "l" inst~>l ) returnList)
				)
				returnList = cons( list( "m" inst~>m ) returnList)
				returnList = cons( list( "perim" inst~>perim ) returnList)
				returnList = cons( list( "removeTap" inst~>removeTap ) returnList)
				returnList = cons( list( "isLD" inst~>isLD ) returnList)
			)
			( "ndio_nosal"
				when( evalstring( "inst->fixedLayout != \"Yes\" && inst->calcParam!=\"area\"" )
					returnList = cons( list( "area" inst~>area ) returnList)
				)
				when( evalstring( "inst->widthVisible == \"Yes\" && inst->calcParam!=\"width\"" )
					returnList = cons( list( "w" inst~>w ) returnList)
				)
				when( evalstring( "inst->fixedLayout != \"Yes\" && inst->calcParam!=\"length\"" )
					returnList = cons( list( "l" inst~>l ) returnList)
				)
				returnList = cons( list( "m" inst~>m ) returnList)
				returnList = cons( list( "perim" inst~>perim ) returnList)
				returnList = cons( list( "removeTap" inst~>removeTap ) returnList)
			)
			( "ndio_sal"
				when( evalstring( "inst->fixedLayout != \"Yes\" && inst->calcParam!=\"area\"" )
					returnList = cons( list( "area" inst~>area ) returnList)
				)
				when( evalstring( "inst->widthVisible == \"Yes\" && inst->calcParam!=\"width\"" )
					returnList = cons( list( "w" inst~>w ) returnList)
				)
				when( evalstring( "inst->fixedLayout != \"Yes\" && inst->calcParam!=\"length\"" )
					returnList = cons( list( "l" inst~>l ) returnList)
				)
				returnList = cons( list( "m" inst~>m ) returnList)
				returnList = cons( list( "perim" inst~>perim ) returnList)
				returnList = cons( list( "removeTap" inst~>removeTap ) returnList)
			)
			( "nmos_18"
				returnList = cons( list( "newPcellStyle" inst~>newPcellStyle ) returnList)
				returnList = cons( list( "w" inst~>w ) returnList)
				returnList = cons( list( "l" inst~>l ) returnList)
				when( evalstring( "inst->applyThresh == nil" )
					returnList = cons( list( "nf" inst~>nf ) returnList)
				)
				returnList = cons( list( "m" inst~>m ) returnList)
				returnList = cons( list( "polyConnStyle" inst~>polyConnStyle ) returnList)
				returnList = cons( list( "mEndcapWidth" inst~>mEndcapWidth ) returnList)
				returnList = cons( list( "mPolyToDiffSpace" inst~>mPolyToDiffSpace ) returnList)
				returnList = cons( list( "sSDContToG" inst~>sSDContToG ) returnList)
				returnList = cons( list( "sDContToG" inst~>sDContToG ) returnList)
				returnList = cons( list( "connectLeftTapToSrc" inst~>connectLeftTapToSrc ) returnList)
				returnList = cons( list( "connectRightTapToSrc" inst~>connectRightTapToSrc ) returnList)
				returnList = cons( list( "leftTapM1" inst~>leftTapM1 ) returnList)
				returnList = cons( list( "topTapM1" inst~>topTapM1 ) returnList)
				returnList = cons( list( "bottomTapM1" inst~>bottomTapM1 ) returnList)
				returnList = cons( list( "rightTapM1" inst~>rightTapM1 ) returnList)
				returnList = cons( list( "abuttedTapM1" inst~>abuttedTapM1 ) returnList)
				returnList = cons( list( "connectTapToSrc" inst~>connectTapToSrc ) returnList)
				returnList = cons( list( "gatesPerTap" inst~>gatesPerTap ) returnList)
				returnList = cons( list( "cleanDrc" inst~>cleanDrc ) returnList)
				returnList = cons( list( "isLD" inst~>isLD ) returnList)
			)
			( "nmos_18_iso"
				returnList = cons( list( "w" inst~>w ) returnList)
				returnList = cons( list( "l" inst~>l ) returnList)
				when( evalstring( "inst->applyThresh == nil" )
					returnList = cons( list( "nf" inst~>nf ) returnList)
				)
				returnList = cons( list( "m" inst~>m ) returnList)
				returnList = cons( list( "polyConnStyle" inst~>polyConnStyle ) returnList)
				returnList = cons( list( "mEndcapWidth" inst~>mEndcapWidth ) returnList)
				returnList = cons( list( "mPolyToDiffSpace" inst~>mPolyToDiffSpace ) returnList)
			)
			( "nmos_33"
				returnList = cons( list( "newPcellStyle" inst~>newPcellStyle ) returnList)
				returnList = cons( list( "w" inst~>w ) returnList)
				returnList = cons( list( "l" inst~>l ) returnList)
				when( evalstring( "inst->applyThresh == nil" )
					returnList = cons( list( "nf" inst~>nf ) returnList)
				)
				returnList = cons( list( "m" inst~>m ) returnList)
				returnList = cons( list( "polyConnStyle" inst~>polyConnStyle ) returnList)
				returnList = cons( list( "mEndcapWidth" inst~>mEndcapWidth ) returnList)
				returnList = cons( list( "mPolyToDiffSpace" inst~>mPolyToDiffSpace ) returnList)
				returnList = cons( list( "sSDContToG" inst~>sSDContToG ) returnList)
				returnList = cons( list( "sDContToG" inst~>sDContToG ) returnList)
				returnList = cons( list( "connectLeftTapToSrc" inst~>connectLeftTapToSrc ) returnList)
				returnList = cons( list( "connectRightTapToSrc" inst~>connectRightTapToSrc ) returnList)
				returnList = cons( list( "leftTapM1" inst~>leftTapM1 ) returnList)
				returnList = cons( list( "topTapM1" inst~>topTapM1 ) returnList)
				returnList = cons( list( "bottomTapM1" inst~>bottomTapM1 ) returnList)
				returnList = cons( list( "rightTapM1" inst~>rightTapM1 ) returnList)
				returnList = cons( list( "abuttedTapM1" inst~>abuttedTapM1 ) returnList)
				returnList = cons( list( "connectTapToSrc" inst~>connectTapToSrc ) returnList)
				returnList = cons( list( "gatesPerTap" inst~>gatesPerTap ) returnList)
				returnList = cons( list( "cleanDrc" inst~>cleanDrc ) returnList)
				returnList = cons( list( "isLD" inst~>isLD ) returnList)
			)
			( "nmos_33_iso"
				returnList = cons( list( "m" inst~>m ) returnList)
				returnList = cons( list( "w" inst~>w ) returnList)
				returnList = cons( list( "l" inst~>l ) returnList)
				when( evalstring( "inst->applyThresh == nil" )
					returnList = cons( list( "fingers" inst~>fingers ) returnList)
				)
			)
			( "nmos_5V"
				returnList = cons( list( "newPcellStyle" inst~>newPcellStyle ) returnList)
				returnList = cons( list( "w" inst~>w ) returnList)
				returnList = cons( list( "l" inst~>l ) returnList)
				when( evalstring( "inst->applyThresh == nil" )
					returnList = cons( list( "nf" inst~>nf ) returnList)
				)
				returnList = cons( list( "m" inst~>m ) returnList)
				returnList = cons( list( "polyConnStyle" inst~>polyConnStyle ) returnList)
				returnList = cons( list( "mEndcapWidth" inst~>mEndcapWidth ) returnList)
				returnList = cons( list( "mPolyToDiffSpace" inst~>mPolyToDiffSpace ) returnList)
				returnList = cons( list( "sSDContToG" inst~>sSDContToG ) returnList)
				returnList = cons( list( "sDContToG" inst~>sDContToG ) returnList)
				returnList = cons( list( "connectLeftTapToSrc" inst~>connectLeftTapToSrc ) returnList)
				returnList = cons( list( "connectRightTapToSrc" inst~>connectRightTapToSrc ) returnList)
				returnList = cons( list( "leftTapM1" inst~>leftTapM1 ) returnList)
				returnList = cons( list( "topTapM1" inst~>topTapM1 ) returnList)
				returnList = cons( list( "bottomTapM1" inst~>bottomTapM1 ) returnList)
				returnList = cons( list( "rightTapM1" inst~>rightTapM1 ) returnList)
				returnList = cons( list( "abuttedTapM1" inst~>abuttedTapM1 ) returnList)
				returnList = cons( list( "connectTapToSrc" inst~>connectTapToSrc ) returnList)
				returnList = cons( list( "gatesPerTap" inst~>gatesPerTap ) returnList)
				returnList = cons( list( "cleanDrc" inst~>cleanDrc ) returnList)
				returnList = cons( list( "isLD" inst~>isLD ) returnList)
			)
			( "nmos_5V_iso"
				returnList = cons( list( "newPcellStyle" inst~>newPcellStyle ) returnList)
				returnList = cons( list( "w" inst~>w ) returnList)
				returnList = cons( list( "l" inst~>l ) returnList)
				when( evalstring( "inst->applyThresh == nil" )
					returnList = cons( list( "nf" inst~>nf ) returnList)
				)
				returnList = cons( list( "m" inst~>m ) returnList)
				returnList = cons( list( "polyConnStyle" inst~>polyConnStyle ) returnList)
				returnList = cons( list( "mEndcapWidth" inst~>mEndcapWidth ) returnList)
				returnList = cons( list( "mPolyToDiffSpace" inst~>mPolyToDiffSpace ) returnList)
				returnList = cons( list( "sSDContToG" inst~>sSDContToG ) returnList)
				returnList = cons( list( "sDContToG" inst~>sDContToG ) returnList)
				returnList = cons( list( "connectLeftTapToSrc" inst~>connectLeftTapToSrc ) returnList)
				returnList = cons( list( "connectRightTapToSrc" inst~>connectRightTapToSrc ) returnList)
				returnList = cons( list( "leftTapM1" inst~>leftTapM1 ) returnList)
				returnList = cons( list( "topTapM1" inst~>topTapM1 ) returnList)
				returnList = cons( list( "bottomTapM1" inst~>bottomTapM1 ) returnList)
				returnList = cons( list( "rightTapM1" inst~>rightTapM1 ) returnList)
				returnList = cons( list( "abuttedTapM1" inst~>abuttedTapM1 ) returnList)
				returnList = cons( list( "connectTapToSrc" inst~>connectTapToSrc ) returnList)
				returnList = cons( list( "gatesPerTap" inst~>gatesPerTap ) returnList)
				returnList = cons( list( "cleanDrc" inst~>cleanDrc ) returnList)
			)
			( "nmos_native"
				returnList = cons( list( "w" inst~>w ) returnList)
				returnList = cons( list( "l" inst~>l ) returnList)
				when( evalstring( "inst->applyThresh == nil" )
					returnList = cons( list( "nf" inst~>nf ) returnList)
				)
				returnList = cons( list( "m" inst~>m ) returnList)
				returnList = cons( list( "polyConnStyle" inst~>polyConnStyle ) returnList)
				returnList = cons( list( "mEndcapWidth" inst~>mEndcapWidth ) returnList)
				returnList = cons( list( "mPolyToDiffSpace" inst~>mPolyToDiffSpace ) returnList)
			)
			( "nmos_native_33"
				returnList = cons( list( "m" inst~>m ) returnList)
				returnList = cons( list( "w" inst~>w ) returnList)
				returnList = cons( list( "l" inst~>l ) returnList)
				when( evalstring( "inst->applyThresh == nil" )
					returnList = cons( list( "fingers" inst~>fingers ) returnList)
				)
			)
			( "nmos_native_5"
				returnList = cons( list( "w" inst~>w ) returnList)
				returnList = cons( list( "l" inst~>l ) returnList)
				when( evalstring( "inst->applyThresh == nil" )
					returnList = cons( list( "nf" inst~>nf ) returnList)
				)
				returnList = cons( list( "m" inst~>m ) returnList)
				returnList = cons( list( "polyConnStyle" inst~>polyConnStyle ) returnList)
				returnList = cons( list( "mEndcapWidth" inst~>mEndcapWidth ) returnList)
				returnList = cons( list( "mPolyToDiffSpace" inst~>mPolyToDiffSpace ) returnList)
			)
			( "nwldio"
				when( evalstring( "inst->fixedLayout != \"Yes\" && inst->calcParam!=\"area\"" )
					returnList = cons( list( "area" inst~>area ) returnList)
				)
				when( evalstring( "inst->widthVisible == \"Yes\" && inst->calcParam!=\"width\"" )
					returnList = cons( list( "w" inst~>w ) returnList)
				)
				when( evalstring( "inst->fixedLayout != \"Yes\" && inst->calcParam!=\"length\"" )
					returnList = cons( list( "l" inst~>l ) returnList)
				)
				returnList = cons( list( "m" inst~>m ) returnList)
				returnList = cons( list( "perim" inst~>perim ) returnList)
				returnList = cons( list( "removeTap" inst~>removeTap ) returnList)
			)
			( "nwldio_33"
				when( evalstring( "inst->fixedLayout != \"Yes\" && inst->calcParam!=\"area\"" )
					returnList = cons( list( "area" inst~>area ) returnList)
				)
				when( evalstring( "inst->widthVisible == \"Yes\" && inst->calcParam!=\"width\"" )
					returnList = cons( list( "w" inst~>w ) returnList)
				)
				when( evalstring( "inst->fixedLayout != \"Yes\" && inst->calcParam!=\"length\"" )
					returnList = cons( list( "l" inst~>l ) returnList)
				)
				returnList = cons( list( "m" inst~>m ) returnList)
				returnList = cons( list( "perim" inst~>perim ) returnList)
				returnList = cons( list( "removeTap" inst~>removeTap ) returnList)
			)
			( "p18hvt"
				returnList = cons( list( "w" inst~>w ) returnList)
				returnList = cons( list( "l" inst~>l ) returnList)
				when( evalstring( "inst->applyThresh == nil" )
					returnList = cons( list( "nf" inst~>nf ) returnList)
				)
				returnList = cons( list( "m" inst~>m ) returnList)
				returnList = cons( list( "polyConnStyle" inst~>polyConnStyle ) returnList)
				returnList = cons( list( "mEndcapWidth" inst~>mEndcapWidth ) returnList)
				returnList = cons( list( "mPolyToDiffSpace" inst~>mPolyToDiffSpace ) returnList)
			)
			( "p18lvt"
				returnList = cons( list( "w" inst~>w ) returnList)
				returnList = cons( list( "l" inst~>l ) returnList)
				when( evalstring( "inst->applyThresh == nil" )
					returnList = cons( list( "nf" inst~>nf ) returnList)
				)
				returnList = cons( list( "m" inst~>m ) returnList)
				returnList = cons( list( "polyConnStyle" inst~>polyConnStyle ) returnList)
				returnList = cons( list( "mEndcapWidth" inst~>mEndcapWidth ) returnList)
				returnList = cons( list( "mPolyToDiffSpace" inst~>mPolyToDiffSpace ) returnList)
			)
			( "pdio_33"
				when( evalstring( "inst->fixedLayout != \"Yes\" && inst->calcParam!=\"area\"" )
					returnList = cons( list( "area" inst~>area ) returnList)
				)
				when( evalstring( "inst->widthVisible == \"Yes\" && inst->calcParam!=\"width\"" )
					returnList = cons( list( "w" inst~>w ) returnList)
				)
				when( evalstring( "inst->fixedLayout != \"Yes\" && inst->calcParam!=\"length\"" )
					returnList = cons( list( "l" inst~>l ) returnList)
				)
				returnList = cons( list( "m" inst~>m ) returnList)
				returnList = cons( list( "perim" inst~>perim ) returnList)
				returnList = cons( list( "removeTap" inst~>removeTap ) returnList)
				returnList = cons( list( "isLD" inst~>isLD ) returnList)
			)
			( "pdio_nosal"
				when( evalstring( "inst->fixedLayout != \"Yes\" && inst->calcParam!=\"area\"" )
					returnList = cons( list( "area" inst~>area ) returnList)
				)
				when( evalstring( "inst->widthVisible == \"Yes\" && inst->calcParam!=\"width\"" )
					returnList = cons( list( "w" inst~>w ) returnList)
				)
				when( evalstring( "inst->fixedLayout != \"Yes\" && inst->calcParam!=\"length\"" )
					returnList = cons( list( "l" inst~>l ) returnList)
				)
				returnList = cons( list( "m" inst~>m ) returnList)
				returnList = cons( list( "perim" inst~>perim ) returnList)
				returnList = cons( list( "removeTap" inst~>removeTap ) returnList)
			)
			( "pdio_sal"
				when( evalstring( "inst->fixedLayout != \"Yes\" && inst->calcParam!=\"area\"" )
					returnList = cons( list( "area" inst~>area ) returnList)
				)
				when( evalstring( "inst->widthVisible == \"Yes\" && inst->calcParam!=\"width\"" )
					returnList = cons( list( "w" inst~>w ) returnList)
				)
				when( evalstring( "inst->fixedLayout != \"Yes\" && inst->calcParam!=\"length\"" )
					returnList = cons( list( "l" inst~>l ) returnList)
				)
				returnList = cons( list( "m" inst~>m ) returnList)
				returnList = cons( list( "perim" inst~>perim ) returnList)
				returnList = cons( list( "removeTap" inst~>removeTap ) returnList)
			)
			( "pmos_18"
				returnList = cons( list( "newPcellStyle" inst~>newPcellStyle ) returnList)
				returnList = cons( list( "w" inst~>w ) returnList)
				returnList = cons( list( "l" inst~>l ) returnList)
				when( evalstring( "inst->applyThresh == nil" )
					returnList = cons( list( "nf" inst~>nf ) returnList)
				)
				returnList = cons( list( "m" inst~>m ) returnList)
				returnList = cons( list( "polyConnStyle" inst~>polyConnStyle ) returnList)
				returnList = cons( list( "mEndcapWidth" inst~>mEndcapWidth ) returnList)
				returnList = cons( list( "mPolyToDiffSpace" inst~>mPolyToDiffSpace ) returnList)
				returnList = cons( list( "sSDContToG" inst~>sSDContToG ) returnList)
				returnList = cons( list( "sDContToG" inst~>sDContToG ) returnList)
				returnList = cons( list( "connectLeftTapToSrc" inst~>connectLeftTapToSrc ) returnList)
				returnList = cons( list( "connectRightTapToSrc" inst~>connectRightTapToSrc ) returnList)
				returnList = cons( list( "leftTapM1" inst~>leftTapM1 ) returnList)
				returnList = cons( list( "topTapM1" inst~>topTapM1 ) returnList)
				returnList = cons( list( "bottomTapM1" inst~>bottomTapM1 ) returnList)
				returnList = cons( list( "rightTapM1" inst~>rightTapM1 ) returnList)
				returnList = cons( list( "abuttedTapM1" inst~>abuttedTapM1 ) returnList)
				returnList = cons( list( "connectTapToSrc" inst~>connectTapToSrc ) returnList)
				returnList = cons( list( "gatesPerTap" inst~>gatesPerTap ) returnList)
				returnList = cons( list( "cleanDrc" inst~>cleanDrc ) returnList)
				returnList = cons( list( "isLD" inst~>isLD ) returnList)
			)
			( "pmos_33"
				returnList = cons( list( "newPcellStyle" inst~>newPcellStyle ) returnList)
				returnList = cons( list( "w" inst~>w ) returnList)
				returnList = cons( list( "l" inst~>l ) returnList)
				when( evalstring( "inst->applyThresh == nil" )
					returnList = cons( list( "nf" inst~>nf ) returnList)
				)
				returnList = cons( list( "m" inst~>m ) returnList)
				returnList = cons( list( "polyConnStyle" inst~>polyConnStyle ) returnList)
				returnList = cons( list( "mEndcapWidth" inst~>mEndcapWidth ) returnList)
				returnList = cons( list( "mPolyToDiffSpace" inst~>mPolyToDiffSpace ) returnList)
				returnList = cons( list( "sSDContToG" inst~>sSDContToG ) returnList)
				returnList = cons( list( "sDContToG" inst~>sDContToG ) returnList)
				returnList = cons( list( "connectLeftTapToSrc" inst~>connectLeftTapToSrc ) returnList)
				returnList = cons( list( "connectRightTapToSrc" inst~>connectRightTapToSrc ) returnList)
				returnList = cons( list( "leftTapM1" inst~>leftTapM1 ) returnList)
				returnList = cons( list( "topTapM1" inst~>topTapM1 ) returnList)
				returnList = cons( list( "bottomTapM1" inst~>bottomTapM1 ) returnList)
				returnList = cons( list( "rightTapM1" inst~>rightTapM1 ) returnList)
				returnList = cons( list( "abuttedTapM1" inst~>abuttedTapM1 ) returnList)
				returnList = cons( list( "connectTapToSrc" inst~>connectTapToSrc ) returnList)
				returnList = cons( list( "gatesPerTap" inst~>gatesPerTap ) returnList)
				returnList = cons( list( "cleanDrc" inst~>cleanDrc ) returnList)
				returnList = cons( list( "isLD" inst~>isLD ) returnList)
			)
			( "pmos_5V"
				returnList = cons( list( "newPcellStyle" inst~>newPcellStyle ) returnList)
				returnList = cons( list( "w" inst~>w ) returnList)
				returnList = cons( list( "l" inst~>l ) returnList)
				when( evalstring( "inst->applyThresh == nil" )
					returnList = cons( list( "nf" inst~>nf ) returnList)
				)
				returnList = cons( list( "m" inst~>m ) returnList)
				returnList = cons( list( "polyConnStyle" inst~>polyConnStyle ) returnList)
				returnList = cons( list( "mEndcapWidth" inst~>mEndcapWidth ) returnList)
				returnList = cons( list( "mPolyToDiffSpace" inst~>mPolyToDiffSpace ) returnList)
				returnList = cons( list( "sSDContToG" inst~>sSDContToG ) returnList)
				returnList = cons( list( "sDContToG" inst~>sDContToG ) returnList)
				returnList = cons( list( "connectLeftTapToSrc" inst~>connectLeftTapToSrc ) returnList)
				returnList = cons( list( "connectRightTapToSrc" inst~>connectRightTapToSrc ) returnList)
				returnList = cons( list( "leftTapM1" inst~>leftTapM1 ) returnList)
				returnList = cons( list( "topTapM1" inst~>topTapM1 ) returnList)
				returnList = cons( list( "bottomTapM1" inst~>bottomTapM1 ) returnList)
				returnList = cons( list( "rightTapM1" inst~>rightTapM1 ) returnList)
				returnList = cons( list( "abuttedTapM1" inst~>abuttedTapM1 ) returnList)
				returnList = cons( list( "connectTapToSrc" inst~>connectTapToSrc ) returnList)
				returnList = cons( list( "gatesPerTap" inst~>gatesPerTap ) returnList)
				returnList = cons( list( "cleanDrc" inst~>cleanDrc ) returnList)
				returnList = cons( list( "isLD" inst~>isLD ) returnList)
			)
			( "rm1"
				when( evalstring( "inst->calculatedParam != \"Resistance\"" )
					returnList = cons( list( "r" inst~>r ) returnList)
				)
				when( evalstring( "inst->calculatedParam != \"Length\"" )
					returnList = cons( list( "segLength" inst~>segLength ) returnList)
				)
				when( evalstring( "inst->calculatedParam != \"Width\"" )
					returnList = cons( list( "w" inst~>w ) returnList)
				)
				returnList = cons( list( "segments" inst~>segments ) returnList)
				returnList = cons( list( "segConfig" inst~>segConfig ) returnList)
				returnList = cons( list( "sf" inst~>sf ) returnList)
				returnList = cons( list( "isMinTabLength" inst~>isMinTabLength ) returnList)
			)
			( "rm2"
				when( evalstring( "inst->calculatedParam != \"Resistance\"" )
					returnList = cons( list( "r" inst~>r ) returnList)
				)
				when( evalstring( "inst->calculatedParam != \"Length\"" )
					returnList = cons( list( "segLength" inst~>segLength ) returnList)
				)
				when( evalstring( "inst->calculatedParam != \"Width\"" )
					returnList = cons( list( "w" inst~>w ) returnList)
				)
				returnList = cons( list( "segments" inst~>segments ) returnList)
				returnList = cons( list( "segConfig" inst~>segConfig ) returnList)
				returnList = cons( list( "sf" inst~>sf ) returnList)
				returnList = cons( list( "isMinTabLength" inst~>isMinTabLength ) returnList)
			)
			( "rm3"
				when( evalstring( "inst->calculatedParam != \"Resistance\"" )
					returnList = cons( list( "r" inst~>r ) returnList)
				)
				when( evalstring( "inst->calculatedParam != \"Length\"" )
					returnList = cons( list( "segLength" inst~>segLength ) returnList)
				)
				when( evalstring( "inst->calculatedParam != \"Width\"" )
					returnList = cons( list( "w" inst~>w ) returnList)
				)
				returnList = cons( list( "segments" inst~>segments ) returnList)
				returnList = cons( list( "segConfig" inst~>segConfig ) returnList)
				returnList = cons( list( "sf" inst~>sf ) returnList)
				returnList = cons( list( "isMinTabLength" inst~>isMinTabLength ) returnList)
			)
			( "rmL"
				when( evalstring( "inst->calculatedParam != \"Resistance\"" )
					returnList = cons( list( "r" inst~>r ) returnList)
				)
				when( evalstring( "inst->calculatedParam != \"Length\"" )
					returnList = cons( list( "segLength" inst~>segLength ) returnList)
				)
				when( evalstring( "inst->calculatedParam != \"Width\"" )
					returnList = cons( list( "w" inst~>w ) returnList)
				)
				returnList = cons( list( "segments" inst~>segments ) returnList)
				returnList = cons( list( "segConfig" inst~>segConfig ) returnList)
				returnList = cons( list( "sf" inst~>sf ) returnList)
				returnList = cons( list( "isMinTabLength" inst~>isMinTabLength ) returnList)
			)
			( "rnlpoly2t"
				when( evalstring( "inst->calculatedParam != \"Resistance\"" )
					returnList = cons( list( "r" inst~>r ) returnList)
				)
				when( evalstring( "inst->calculatedParam != \"Length\"" )
					returnList = cons( list( "segLength" inst~>segLength ) returnList)
				)
				when( evalstring( "inst->calculatedParam != \"Width\"" )
					returnList = cons( list( "w" inst~>w ) returnList)
				)
				returnList = cons( list( "segments" inst~>segments ) returnList)
				returnList = cons( list( "segConfig" inst~>segConfig ) returnList)
				returnList = cons( list( "sf" inst~>sf ) returnList)
			)
			( "rnlpoly3t"
				when( evalstring( "inst->calculatedParam != \"Resistance\"" )
					returnList = cons( list( "r" inst~>r ) returnList)
				)
				when( evalstring( "inst->calculatedParam != \"Length\"" )
					returnList = cons( list( "segLength" inst~>segLength ) returnList)
				)
				when( evalstring( "inst->calculatedParam != \"Width\"" )
					returnList = cons( list( "w" inst~>w ) returnList)
				)
				returnList = cons( list( "segments" inst~>segments ) returnList)
				returnList = cons( list( "segConfig" inst~>segConfig ) returnList)
				returnList = cons( list( "sf" inst~>sf ) returnList)
			)
			( "rnmpoly2t"
				when( evalstring( "inst->calculatedParam != \"Resistance\"" )
					returnList = cons( list( "r" inst~>r ) returnList)
				)
				when( evalstring( "inst->calculatedParam != \"Length\"" )
					returnList = cons( list( "segLength" inst~>segLength ) returnList)
				)
				when( evalstring( "inst->calculatedParam != \"Width\"" )
					returnList = cons( list( "w" inst~>w ) returnList)
				)
				returnList = cons( list( "segments" inst~>segments ) returnList)
				returnList = cons( list( "segConfig" inst~>segConfig ) returnList)
				returnList = cons( list( "sf" inst~>sf ) returnList)
				returnList = cons( list( "esdRes" inst~>esdRes ) returnList)
			)
			( "rnmpoly3t"
				when( evalstring( "inst->calculatedParam != \"Resistance\"" )
					returnList = cons( list( "r" inst~>r ) returnList)
				)
				when( evalstring( "inst->calculatedParam != \"Length\"" )
					returnList = cons( list( "segLength" inst~>segLength ) returnList)
				)
				when( evalstring( "inst->calculatedParam != \"Width\"" )
					returnList = cons( list( "w" inst~>w ) returnList)
				)
				returnList = cons( list( "segments" inst~>segments ) returnList)
				returnList = cons( list( "segConfig" inst~>segConfig ) returnList)
				returnList = cons( list( "sf" inst~>sf ) returnList)
				returnList = cons( list( "esdRes" inst~>esdRes ) returnList)
				returnList = cons( list( "r3_flag" inst~>r3_flag ) returnList)
			)
			( "rnplus2t"
				when( evalstring( "inst->calculatedParam != \"Resistance\"" )
					returnList = cons( list( "r" inst~>r ) returnList)
				)
				when( evalstring( "inst->calculatedParam != \"Length\"" )
					returnList = cons( list( "segLength" inst~>segLength ) returnList)
				)
				when( evalstring( "inst->calculatedParam != \"Width\"" )
					returnList = cons( list( "w" inst~>w ) returnList)
				)
				returnList = cons( list( "segments" inst~>segments ) returnList)
				returnList = cons( list( "segConfig" inst~>segConfig ) returnList)
				returnList = cons( list( "sf" inst~>sf ) returnList)
			)
			( "rnplus3t"
				when( evalstring( "inst->calculatedParam != \"Resistance\"" )
					returnList = cons( list( "r" inst~>r ) returnList)
				)
				when( evalstring( "inst->calculatedParam != \"Length\"" )
					returnList = cons( list( "segLength" inst~>segLength ) returnList)
				)
				when( evalstring( "inst->calculatedParam != \"Width\"" )
					returnList = cons( list( "w" inst~>w ) returnList)
				)
				returnList = cons( list( "segments" inst~>segments ) returnList)
				returnList = cons( list( "segConfig" inst~>segConfig ) returnList)
				returnList = cons( list( "sf" inst~>sf ) returnList)
			)
			( "rnplus_sal2t"
				when( evalstring( "inst->calculatedParam != \"Resistance\"" )
					returnList = cons( list( "r" inst~>r ) returnList)
				)
				when( evalstring( "inst->calculatedParam != \"Length\"" )
					returnList = cons( list( "segLength" inst~>segLength ) returnList)
				)
				when( evalstring( "inst->calculatedParam != \"Width\"" )
					returnList = cons( list( "w" inst~>w ) returnList)
				)
				returnList = cons( list( "segments" inst~>segments ) returnList)
				returnList = cons( list( "segConfig" inst~>segConfig ) returnList)
				returnList = cons( list( "sf" inst~>sf ) returnList)
			)
			( "rnplus_sal3t"
				when( evalstring( "inst->calculatedParam != \"Resistance\"" )
					returnList = cons( list( "r" inst~>r ) returnList)
				)
				when( evalstring( "inst->calculatedParam != \"Length\"" )
					returnList = cons( list( "segLength" inst~>segLength ) returnList)
				)
				when( evalstring( "inst->calculatedParam != \"Width\"" )
					returnList = cons( list( "w" inst~>w ) returnList)
				)
				returnList = cons( list( "segments" inst~>segments ) returnList)
				returnList = cons( list( "segConfig" inst~>segConfig ) returnList)
				returnList = cons( list( "sf" inst~>sf ) returnList)
			)
			( "rnwell_AA2t"
				when( evalstring( "inst->calculatedParam != \"Resistance\"" )
					returnList = cons( list( "r" inst~>r ) returnList)
				)
				when( evalstring( "inst->calculatedParam != \"Length\"" )
					returnList = cons( list( "segLength" inst~>segLength ) returnList)
				)
				when( evalstring( "inst->calculatedParam != \"Width\"" )
					returnList = cons( list( "w" inst~>w ) returnList)
				)
				returnList = cons( list( "segments" inst~>segments ) returnList)
				returnList = cons( list( "segConfig" inst~>segConfig ) returnList)
				returnList = cons( list( "sf" inst~>sf ) returnList)
			)
			( "rnwell_AA3t"
				when( evalstring( "inst->calculatedParam != \"Resistance\"" )
					returnList = cons( list( "r" inst~>r ) returnList)
				)
				when( evalstring( "inst->calculatedParam != \"Length\"" )
					returnList = cons( list( "segLength" inst~>segLength ) returnList)
				)
				when( evalstring( "inst->calculatedParam != \"Width\"" )
					returnList = cons( list( "w" inst~>w ) returnList)
				)
				returnList = cons( list( "segments" inst~>segments ) returnList)
				returnList = cons( list( "segConfig" inst~>segConfig ) returnList)
				returnList = cons( list( "sf" inst~>sf ) returnList)
			)
			( "rnwell_STI2t"
				when( evalstring( "inst->calculatedParam != \"Resistance\"" )
					returnList = cons( list( "r" inst~>r ) returnList)
				)
				when( evalstring( "inst->calculatedParam != \"Length\"" )
					returnList = cons( list( "segLength" inst~>segLength ) returnList)
				)
				when( evalstring( "inst->calculatedParam != \"Width\"" )
					returnList = cons( list( "w" inst~>w ) returnList)
				)
				returnList = cons( list( "segments" inst~>segments ) returnList)
				returnList = cons( list( "segConfig" inst~>segConfig ) returnList)
				returnList = cons( list( "sf" inst~>sf ) returnList)
			)
			( "rnwell_STI3t"
				when( evalstring( "inst->calculatedParam != \"Resistance\"" )
					returnList = cons( list( "r" inst~>r ) returnList)
				)
				when( evalstring( "inst->calculatedParam != \"Length\"" )
					returnList = cons( list( "segLength" inst~>segLength ) returnList)
				)
				when( evalstring( "inst->calculatedParam != \"Width\"" )
					returnList = cons( list( "w" inst~>w ) returnList)
				)
				returnList = cons( list( "segments" inst~>segments ) returnList)
				returnList = cons( list( "segConfig" inst~>segConfig ) returnList)
				returnList = cons( list( "sf" inst~>sf ) returnList)
			)
			( "rphpoly2t"
				when( evalstring( "inst->calculatedParam != \"Resistance\"" )
					returnList = cons( list( "r" inst~>r ) returnList)
				)
				when( evalstring( "inst->calculatedParam != \"Length\"" )
					returnList = cons( list( "segLength" inst~>segLength ) returnList)
				)
				when( evalstring( "inst->calculatedParam != \"Width\"" )
					returnList = cons( list( "w" inst~>w ) returnList)
				)
				returnList = cons( list( "segments" inst~>segments ) returnList)
				returnList = cons( list( "segConfig" inst~>segConfig ) returnList)
				returnList = cons( list( "sf" inst~>sf ) returnList)
			)
			( "rphpoly3t"
				when( evalstring( "inst->calculatedParam != \"Resistance\"" )
					returnList = cons( list( "r" inst~>r ) returnList)
				)
				when( evalstring( "inst->calculatedParam != \"Length\"" )
					returnList = cons( list( "segLength" inst~>segLength ) returnList)
				)
				when( evalstring( "inst->calculatedParam != \"Width\"" )
					returnList = cons( list( "w" inst~>w ) returnList)
				)
				returnList = cons( list( "segments" inst~>segments ) returnList)
				returnList = cons( list( "segConfig" inst~>segConfig ) returnList)
				returnList = cons( list( "sf" inst~>sf ) returnList)
				returnList = cons( list( "r3_flag" inst~>r3_flag ) returnList)
			)
			( "rplpoly2t"
				when( evalstring( "inst->calculatedParam != \"Resistance\"" )
					returnList = cons( list( "r" inst~>r ) returnList)
				)
				when( evalstring( "inst->calculatedParam != \"Length\"" )
					returnList = cons( list( "segLength" inst~>segLength ) returnList)
				)
				when( evalstring( "inst->calculatedParam != \"Width\"" )
					returnList = cons( list( "w" inst~>w ) returnList)
				)
				returnList = cons( list( "segments" inst~>segments ) returnList)
				returnList = cons( list( "segConfig" inst~>segConfig ) returnList)
				returnList = cons( list( "sf" inst~>sf ) returnList)
			)
			( "rplpoly3t"
				when( evalstring( "inst->calculatedParam != \"Resistance\"" )
					returnList = cons( list( "r" inst~>r ) returnList)
				)
				when( evalstring( "inst->calculatedParam != \"Length\"" )
					returnList = cons( list( "segLength" inst~>segLength ) returnList)
				)
				when( evalstring( "inst->calculatedParam != \"Width\"" )
					returnList = cons( list( "w" inst~>w ) returnList)
				)
				returnList = cons( list( "segments" inst~>segments ) returnList)
				returnList = cons( list( "segConfig" inst~>segConfig ) returnList)
				returnList = cons( list( "sf" inst~>sf ) returnList)
			)
			( "rpmpoly2t"
				when( evalstring( "inst->calculatedParam != \"Resistance\"" )
					returnList = cons( list( "r" inst~>r ) returnList)
				)
				when( evalstring( "inst->calculatedParam != \"Length\"" )
					returnList = cons( list( "segLength" inst~>segLength ) returnList)
				)
				when( evalstring( "inst->calculatedParam != \"Width\"" )
					returnList = cons( list( "w" inst~>w ) returnList)
				)
				returnList = cons( list( "segments" inst~>segments ) returnList)
				returnList = cons( list( "segConfig" inst~>segConfig ) returnList)
				returnList = cons( list( "sf" inst~>sf ) returnList)
			)
			( "rpmpoly3t"
				when( evalstring( "inst->calculatedParam != \"Resistance\"" )
					returnList = cons( list( "r" inst~>r ) returnList)
				)
				when( evalstring( "inst->calculatedParam != \"Length\"" )
					returnList = cons( list( "segLength" inst~>segLength ) returnList)
				)
				when( evalstring( "inst->calculatedParam != \"Width\"" )
					returnList = cons( list( "w" inst~>w ) returnList)
				)
				returnList = cons( list( "segments" inst~>segments ) returnList)
				returnList = cons( list( "segConfig" inst~>segConfig ) returnList)
				returnList = cons( list( "sf" inst~>sf ) returnList)
				returnList = cons( list( "r3_flag" inst~>r3_flag ) returnList)
			)
			( "rpplus2t"
				when( evalstring( "inst->calculatedParam != \"Resistance\"" )
					returnList = cons( list( "r" inst~>r ) returnList)
				)
				when( evalstring( "inst->calculatedParam != \"Length\"" )
					returnList = cons( list( "segLength" inst~>segLength ) returnList)
				)
				when( evalstring( "inst->calculatedParam != \"Width\"" )
					returnList = cons( list( "w" inst~>w ) returnList)
				)
				returnList = cons( list( "segments" inst~>segments ) returnList)
				returnList = cons( list( "segConfig" inst~>segConfig ) returnList)
				returnList = cons( list( "sf" inst~>sf ) returnList)
			)
			( "rpplus3t"
				when( evalstring( "inst->calculatedParam != \"Resistance\"" )
					returnList = cons( list( "r" inst~>r ) returnList)
				)
				when( evalstring( "inst->calculatedParam != \"Length\"" )
					returnList = cons( list( "segLength" inst~>segLength ) returnList)
				)
				when( evalstring( "inst->calculatedParam != \"Width\"" )
					returnList = cons( list( "w" inst~>w ) returnList)
				)
				returnList = cons( list( "segments" inst~>segments ) returnList)
				returnList = cons( list( "segConfig" inst~>segConfig ) returnList)
				returnList = cons( list( "sf" inst~>sf ) returnList)
			)
			( "rpplus_sal2t"
				when( evalstring( "inst->calculatedParam != \"Resistance\"" )
					returnList = cons( list( "r" inst~>r ) returnList)
				)
				when( evalstring( "inst->calculatedParam != \"Length\"" )
					returnList = cons( list( "segLength" inst~>segLength ) returnList)
				)
				when( evalstring( "inst->calculatedParam != \"Width\"" )
					returnList = cons( list( "w" inst~>w ) returnList)
				)
				returnList = cons( list( "segments" inst~>segments ) returnList)
				returnList = cons( list( "segConfig" inst~>segConfig ) returnList)
				returnList = cons( list( "sf" inst~>sf ) returnList)
			)
			( "rpplus_sal3t"
				when( evalstring( "inst->calculatedParam != \"Resistance\"" )
					returnList = cons( list( "r" inst~>r ) returnList)
				)
				when( evalstring( "inst->calculatedParam != \"Length\"" )
					returnList = cons( list( "segLength" inst~>segLength ) returnList)
				)
				when( evalstring( "inst->calculatedParam != \"Width\"" )
					returnList = cons( list( "w" inst~>w ) returnList)
				)
				returnList = cons( list( "segments" inst~>segments ) returnList)
				returnList = cons( list( "segConfig" inst~>segConfig ) returnList)
				returnList = cons( list( "sf" inst~>sf ) returnList)
			)
			( "usgcm32t"
				when( evalstring( "inst->userParams != \"Capacitance\"" )
					returnList = cons( list( "c" inst~>c ) returnList)
				)
				when( evalstring( "inst->userParams != \"Length\"" )
					returnList = cons( list( "llayout" inst~>llayout ) returnList)
				)
				returnList = cons( list( "nf" inst~>nf ) returnList)
			)
			( "usgcm33t"
				when( evalstring( "inst->userParams != \"Capacitance\"" )
					returnList = cons( list( "c" inst~>c ) returnList)
				)
				when( evalstring( "inst->userParams != \"Length\"" )
					returnList = cons( list( "llayout" inst~>llayout ) returnList)
				)
				returnList = cons( list( "nf" inst~>nf ) returnList)
			)
			( "vnpn18_5"
				returnList = cons( list( "m" inst~>m ) returnList)
				returnList = cons( list( "areab" inst~>areab ) returnList)
				returnList = cons( list( "areac" inst~>areac ) returnList)
			)
			( "vpnp18_10"
				returnList = cons( list( "m" inst~>m ) returnList)
				returnList = cons( list( "areab" inst~>areab ) returnList)
				returnList = cons( list( "areac" inst~>areac ) returnList)
			)
			( "vpnp18_2"
				returnList = cons( list( "m" inst~>m ) returnList)
				returnList = cons( list( "areab" inst~>areab ) returnList)
				returnList = cons( list( "areac" inst~>areac ) returnList)
			)
			( "vpnp18_5"
				returnList = cons( list( "m" inst~>m ) returnList)
				returnList = cons( list( "areab" inst~>areab ) returnList)
				returnList = cons( list( "areac" inst~>areac ) returnList)
			)
			( "vpnp33_10"
				returnList = cons( list( "m" inst~>m ) returnList)
				returnList = cons( list( "areab" inst~>areab ) returnList)
				returnList = cons( list( "areac" inst~>areac ) returnList)
			)
			( "vpnp33_2"
				returnList = cons( list( "m" inst~>m ) returnList)
				returnList = cons( list( "areab" inst~>areab ) returnList)
				returnList = cons( list( "areac" inst~>areac ) returnList)
			)
			( "vpnp33_5"
				returnList = cons( list( "m" inst~>m ) returnList)
				returnList = cons( list( "areab" inst~>areab ) returnList)
				returnList = cons( list( "areac" inst~>areac ) returnList)
			)
			( t
				nil
			)
		) ;;; end case

		return( returnList )
	)
)

when(isCallable('ciRegisterCustomDeviceFilter)
	ciRegisterCustomDeviceFilter( "Default" 'ts018_scl_prim_AxlCustomDeviceFilter )
)
