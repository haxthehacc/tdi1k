*  -------------------------------------- *
* Defining the default unit for both length and area
*.SCALE meter
*  -------------------------------------- *
.option scale=1

.SUBCKT PAH_18_NA PAD VDDO VSSO VSS VDD PADR
*.PININFO PAD:B VDDO:B VSSO:B VSS:B VDD:B PADR:B
M0 VSSO 8 7 VSSO N L=1.8e-07 W=2e-05 rf_flag=0
M1 PAD 7 VSSO VSSO N L=2.5e-07 W=2.4e-05 rf_flag=0
M2 VSSO 7 PAD VSSO N L=2.5e-07 W=2.4e-05 rf_flag=0
M3 PAD 7 VSSO VSSO N L=2.5e-07 W=2.4e-05 rf_flag=0
M4 VSSO 7 PAD VSSO N L=2.5e-07 W=2.4e-05 rf_flag=0
M5 PAD 7 VSSO VSSO N L=2.5e-07 W=2.4e-05 rf_flag=0
M6 VSSO 7 PAD VSSO N L=2.5e-07 W=2.4e-05 rf_flag=0
M7 PAD 7 VSSO VSSO N L=2.5e-07 W=2.4e-05 rf_flag=0
M8 VSSO 7 PAD VSSO N L=2.5e-07 W=2.4e-05 rf_flag=0
M9 PAD 7 VSSO VSSO N L=2.5e-07 W=2.4e-05 rf_flag=0
M10 VSSO 7 PAD VSSO N L=2.5e-07 W=2.4e-05 rf_flag=0
M11 PAD 7 VSSO VSSO N L=2.5e-07 W=2.4e-05 rf_flag=0
M12 VSSO 7 PAD VSSO N L=2.5e-07 W=2.4e-05 rf_flag=0
M13 PAD 7 VSSO VSSO N L=2.5e-07 W=2.4e-05 rf_flag=0
M14 VSSO 7 PAD VSSO N L=2.5e-07 W=2.4e-05 rf_flag=0
M15 PAD 7 VSSO VSSO N L=2.5e-07 W=2.4e-05 rf_flag=0
M16 VSSO 7 PAD VSSO N L=2.5e-07 W=2.4e-05 rf_flag=0
M17 VSSO 9 PADR VSSO N L=1.8e-07 W=5e-06 rf_flag=0
M18 PADR 9 VSSO VSSO N L=1.8e-07 W=5e-06 rf_flag=0
M19 VSSO 9 PADR VSSO N L=1.8e-07 W=5e-06 rf_flag=0
M20 PADR 9 VSSO VSSO N L=1.8e-07 W=5e-06 rf_flag=0
M21 VSSO 9 PADR VSSO N L=1.8e-07 W=5e-06 rf_flag=0
M22 PADR 9 VSSO VSSO N L=1.8e-07 W=5e-06 rf_flag=0
M23 VSSO 9 PADR VSSO N L=1.8e-07 W=5e-06 rf_flag=0
M24 PADR 9 VSSO VSSO N L=1.8e-07 W=5e-06 rf_flag=0
M25 PAD 15 VSS VSS N L=2.5e-07 W=2.4e-05 rf_flag=0
M26 VSS 15 PAD VSS N L=2.5e-07 W=2.4e-05 rf_flag=0
M27 PAD 15 VSS VSS N L=2.5e-07 W=2.4e-05 rf_flag=0
M28 VSS 15 PAD VSS N L=2.5e-07 W=2.4e-05 rf_flag=0
M29 PAD 15 VSS VSS N L=2.5e-07 W=2.4e-05 rf_flag=0
M30 VSS 15 PAD VSS N L=2.5e-07 W=2.4e-05 rf_flag=0
M31 PAD 15 VSS VSS N L=2.5e-07 W=2.4e-05 rf_flag=0
M32 VSS 15 PAD VSS N L=2.5e-07 W=2.4e-05 rf_flag=0
M33 PAD 15 VSS VSS N L=2.5e-07 W=2.4e-05 rf_flag=0
M34 VSS 15 PAD VSS N L=2.5e-07 W=2.4e-05 rf_flag=0
M35 PAD 15 VSS VSS N L=2.5e-07 W=2.4e-05 rf_flag=0
M36 VSS 15 PAD VSS N L=2.5e-07 W=2.4e-05 rf_flag=0
M37 PAD 15 VSS VSS N L=2.5e-07 W=2.4e-05 rf_flag=0
M38 VSS 15 PAD VSS N L=2.5e-07 W=2.4e-05 rf_flag=0
M39 PAD 15 VSS VSS N L=2.5e-07 W=2.4e-05 rf_flag=0
M40 VSS 15 PAD VSS N L=2.5e-07 W=2.4e-05 rf_flag=0
M41 VSS 14 15 VSS N L=1.8e-07 W=2e-05 rf_flag=0
M42 VMAX VMAX VDDO VMAX P L=1.8e-07 W=1e-05 rf_flag=0
M43 6 10 VMAX VMAX P L=1.8e-07 W=1e-05 rf_flag=0
M44 VMAX 10 6 VMAX P L=1.8e-07 W=1e-05 rf_flag=0
M45 6 10 VMAX VMAX P L=1.8e-07 W=1e-05 rf_flag=0
M46 PAD 6 VDDO VMAX P L=2.5e-07 W=2.08e-05 rf_flag=0
M47 VDDO 6 PAD VMAX P L=2.5e-07 W=2.08e-05 rf_flag=0
M48 PAD 6 VDDO VMAX P L=2.5e-07 W=2.08e-05 rf_flag=0
M49 VDDO 6 PAD VMAX P L=2.5e-07 W=2.08e-05 rf_flag=0
M50 PAD 6 VDDO VMAX P L=2.5e-07 W=2.08e-05 rf_flag=0
M51 VDDO 6 PAD VMAX P L=2.5e-07 W=2.08e-05 rf_flag=0
M52 PAD 6 VDDO VMAX P L=2.5e-07 W=2.08e-05 rf_flag=0
M53 VDDO 6 PAD VMAX P L=2.5e-07 W=2.08e-05 rf_flag=0
M54 PAD 6 VDDO VMAX P L=2.5e-07 W=2.08e-05 rf_flag=0
M55 VDDO 6 PAD VMAX P L=2.5e-07 W=2.08e-05 rf_flag=0
M56 PAD 6 VDDO VMAX P L=2.5e-07 W=2.08e-05 rf_flag=0
M57 VDDO 6 PAD VMAX P L=2.5e-07 W=2.08e-05 rf_flag=0
M58 PAD 6 VDDO VMAX P L=2.5e-07 W=2.08e-05 rf_flag=0
M59 VDDO 6 PAD VMAX P L=2.5e-07 W=2.08e-05 rf_flag=0
M60 PAD 6 VDDO VMAX P L=2.5e-07 W=2.08e-05 rf_flag=0
M61 VDDO 6 PAD VMAX P L=2.5e-07 W=2.08e-05 rf_flag=0
M62 PAD 6 VDDO VMAX P L=2.5e-07 W=2.08e-05 rf_flag=0
M63 VDDO 6 PAD VMAX P L=2.5e-07 W=2.08e-05 rf_flag=0
M64 PAD 6 VDDO VMAX P L=2.5e-07 W=2.08e-05 rf_flag=0
M65 VDDO 6 PAD VMAX P L=2.5e-07 W=2.08e-05 rf_flag=0
M66 VMAX PADR VDDO VMAX P L=1.8e-07 W=1e-05 rf_flag=0
M67 VDDO PADR VMAX VMAX P L=1.8e-07 W=1e-05 rf_flag=0
M68 VMAX PADR VDDO VMAX P L=1.8e-07 W=1e-05 rf_flag=0
M69 PADR 12 VMAX VMAX P L=1.8e-07 W=1e-05 rf_flag=0
M70 VMAX 12 PADR VMAX P L=1.8e-07 W=1e-05 rf_flag=0
M71 PADR 12 VMAX VMAX P L=1.8e-07 W=1e-05 rf_flag=0
R72 VSSO 9 1016.12 L=7e-06 W=3e-06 postlayout=1 $SUB=VSSO $[RE3]
R73 VSSO 10 1016.12 L=7e-06 W=3e-06 postlayout=1 $SUB=VSSO $[RE3]
R74 12 VDDO 1016.12 L=7e-06 W=3e-06 postlayout=1 $SUB=VSSO $[RE3]
R75 PADR PAD 1090.5 L=1.3e-05 W=5e-06 postlayout=1 $SUB=VSSO $[RE3]
R76 8 VMAX 1016.12 L=7e-06 W=3e-06 postlayout=1 $SUB=VSSO $[RE3]
R77 14 VMAX 1016.12 L=7e-06 W=3e-06 postlayout=1 $SUB=VSS $[RE3]
D78 VSS VMAX dwn2psub AREA=2.42956e-09 PJ=0.00022567
D79 VSSO VDDO dwn2psub AREA=3.11153e-09 PJ=0.00161948
D80 VSSO VDDO dwn2psub AREA=3.11153e-09 PJ=0.00161948
D81 VSS VDDO dwn2psub AREA=3.11153e-09 PJ=0.00161948
D82 VSS VDDO dwn2psub AREA=3.11153e-09 PJ=0.00161948
D83 VSS VDDO dwn2psub AREA=3.11153e-09 PJ=0.00161948
D84 VSSO VDDO dwn2psub AREA=3.11153e-09 PJ=0.00161948
D85 VSS VDDO dwn2psub AREA=3.11153e-09 PJ=0.00161948
D86 VSSO VSSO dwn2psub AREA=6.3709e-10 PJ=0.00010544
D87 VSS VSS dwn2psub AREA=6.3709e-10 PJ=0.00010544
D88 VSS VSSO dpnwcpl18 AREA=2.242e-11 PJ=3.25314e-05 nf=1
D89 VSS VSSO dpnwcpl18 AREA=2.242e-11 PJ=3.25314e-05 nf=1
D90 VSS VSSO dpnwcpl18 AREA=2.242e-11 PJ=3.25314e-05 nf=1
D91 VSS VSSO dpnwcpl18 AREA=2.242e-11 PJ=3.25314e-05 nf=1
D92 VSS VSSO dpnwcpl18 AREA=2.242e-11 PJ=3.25314e-05 nf=1
D93 VSS VSSO dpnwcpl18 AREA=2.242e-11 PJ=3.25314e-05 nf=1
D94 VSS VSSO dpnwcpl18 AREA=2.242e-11 PJ=3.25314e-05 nf=1
D95 VSSO VSS dpnwcpl18 AREA=2.242e-11 PJ=3.25314e-05 nf=1
D96 VSSO VSS dpnwcpl18 AREA=2.242e-11 PJ=3.25314e-05 nf=1
D97 VSSO VSS dpnwcpl18 AREA=2.242e-11 PJ=3.25314e-05 nf=1
D98 VSSO VSS dpnwcpl18 AREA=2.242e-11 PJ=3.25314e-05 nf=1
D99 VSSO VSS dpnwcpl18 AREA=2.242e-11 PJ=3.25314e-05 nf=1
D100 VSSO VSS dpnwcpl18 AREA=2.242e-11 PJ=3.25314e-05 nf=1
D101 VSSO VSS dpnwcpl18 AREA=2.242e-11 PJ=3.25314e-05 nf=1
.ENDS

.SUBCKT PAH_50_NA PAD VDDO VSSO VSS VDD PADR
*.PININFO PAD:B VDDO:B VSSO:B VSS:B VDD:B PADR:B
M0 VSSO 9 8 VSSO N5 L=6e-07 W=2e-05 rf_flag=0
M1 PAD 8 VSSO VSSO N5 L=6e-07 W=2.4e-05 rf_flag=0
M2 VSSO 8 PAD VSSO N5 L=6e-07 W=2.4e-05 rf_flag=0
M3 PAD 8 VSSO VSSO N5 L=6e-07 W=2.4e-05 rf_flag=0
M4 VSSO 8 PAD VSSO N5 L=6e-07 W=2.4e-05 rf_flag=0
M5 PAD 8 VSSO VSSO N5 L=6e-07 W=2.4e-05 rf_flag=0
M6 VSSO 8 PAD VSSO N5 L=6e-07 W=2.4e-05 rf_flag=0
M7 PAD 8 VSSO VSSO N5 L=6e-07 W=2.4e-05 rf_flag=0
M8 VSSO 8 PAD VSSO N5 L=6e-07 W=2.4e-05 rf_flag=0
M9 PAD 8 VSSO VSSO N5 L=6e-07 W=2.4e-05 rf_flag=0
M10 VSSO 8 PAD VSSO N5 L=6e-07 W=2.4e-05 rf_flag=0
M11 PAD 8 VSSO VSSO N5 L=6e-07 W=2.4e-05 rf_flag=0
M12 VSSO 8 PAD VSSO N5 L=6e-07 W=2.4e-05 rf_flag=0
M13 PAD 8 VSSO VSSO N5 L=6e-07 W=2.4e-05 rf_flag=0
M14 VSSO 8 PAD VSSO N5 L=6e-07 W=2.4e-05 rf_flag=0
M15 PAD 8 VSSO VSSO N5 L=6e-07 W=2.4e-05 rf_flag=0
M16 VSSO 8 PAD VSSO N5 L=6e-07 W=2.4e-05 rf_flag=0
M17 VSSO 10 PADR VSSO N5 L=6e-07 W=5e-06 rf_flag=0
M18 PADR 10 VSSO VSSO N5 L=6e-07 W=5e-06 rf_flag=0
M19 VSSO 10 PADR VSSO N5 L=6e-07 W=5e-06 rf_flag=0
M20 PADR 10 VSSO VSSO N5 L=6e-07 W=5e-06 rf_flag=0
M21 VSSO 10 PADR VSSO N5 L=6e-07 W=5e-06 rf_flag=0
M22 PADR 10 VSSO VSSO N5 L=6e-07 W=5e-06 rf_flag=0
M23 VSSO 10 PADR VSSO N5 L=6e-07 W=5e-06 rf_flag=0
M24 PADR 10 VSSO VSSO N5 L=6e-07 W=5e-06 rf_flag=0
M25 PAD 15 VSS VSS N5 L=6e-07 W=2.4e-05 rf_flag=0
M26 VSS 15 PAD VSS N5 L=6e-07 W=2.4e-05 rf_flag=0
M27 PAD 15 VSS VSS N5 L=6e-07 W=2.4e-05 rf_flag=0
M28 VSS 15 PAD VSS N5 L=6e-07 W=2.4e-05 rf_flag=0
M29 PAD 15 VSS VSS N5 L=6e-07 W=2.4e-05 rf_flag=0
M30 VSS 15 PAD VSS N5 L=6e-07 W=2.4e-05 rf_flag=0
M31 PAD 15 VSS VSS N5 L=6e-07 W=2.4e-05 rf_flag=0
M32 VSS 15 PAD VSS N5 L=6e-07 W=2.4e-05 rf_flag=0
M33 PAD 15 VSS VSS N5 L=6e-07 W=2.4e-05 rf_flag=0
M34 VSS 15 PAD VSS N5 L=6e-07 W=2.4e-05 rf_flag=0
M35 PAD 15 VSS VSS N5 L=6e-07 W=2.4e-05 rf_flag=0
M36 VSS 15 PAD VSS N5 L=6e-07 W=2.4e-05 rf_flag=0
M37 PAD 15 VSS VSS N5 L=6e-07 W=2.4e-05 rf_flag=0
M38 VSS 15 PAD VSS N5 L=6e-07 W=2.4e-05 rf_flag=0
M39 PAD 15 VSS VSS N5 L=6e-07 W=2.4e-05 rf_flag=0
M40 VSS 15 PAD VSS N5 L=6e-07 W=2.4e-05 rf_flag=0
M41 VSS 14 15 VSS N5 L=6e-07 W=2e-05 rf_flag=0
M42 VMAX VMAX VDDO VMAX P5 L=5e-07 W=1e-05 rf_flag=0
M43 7 6 VMAX VMAX P5 L=5e-07 W=1e-05 rf_flag=0
M44 VMAX 6 7 VMAX P5 L=5e-07 W=1e-05 rf_flag=0
M45 7 6 VMAX VMAX P5 L=5e-07 W=1e-05 rf_flag=0
M46 PAD 7 VDDO VMAX P5 L=5e-07 W=2.08e-05 rf_flag=0
M47 VDDO 7 PAD VMAX P5 L=5e-07 W=2.08e-05 rf_flag=0
M48 PAD 7 VDDO VMAX P5 L=5e-07 W=2.08e-05 rf_flag=0
M49 VDDO 7 PAD VMAX P5 L=5e-07 W=2.08e-05 rf_flag=0
M50 PAD 7 VDDO VMAX P5 L=5e-07 W=2.08e-05 rf_flag=0
M51 VDDO 7 PAD VMAX P5 L=5e-07 W=2.08e-05 rf_flag=0
M52 PAD 7 VDDO VMAX P5 L=5e-07 W=2.08e-05 rf_flag=0
M53 VDDO 7 PAD VMAX P5 L=5e-07 W=2.08e-05 rf_flag=0
M54 PAD 7 VDDO VMAX P5 L=5e-07 W=2.08e-05 rf_flag=0
M55 VDDO 7 PAD VMAX P5 L=5e-07 W=2.08e-05 rf_flag=0
M56 PAD 7 VDDO VMAX P5 L=5e-07 W=2.08e-05 rf_flag=0
M57 VDDO 7 PAD VMAX P5 L=5e-07 W=2.08e-05 rf_flag=0
M58 PAD 7 VDDO VMAX P5 L=5e-07 W=2.08e-05 rf_flag=0
M59 VDDO 7 PAD VMAX P5 L=5e-07 W=2.08e-05 rf_flag=0
M60 PAD 7 VDDO VMAX P5 L=5e-07 W=2.08e-05 rf_flag=0
M61 VDDO 7 PAD VMAX P5 L=5e-07 W=2.08e-05 rf_flag=0
M62 PAD 7 VDDO VMAX P5 L=5e-07 W=2.08e-05 rf_flag=0
M63 VDDO 7 PAD VMAX P5 L=5e-07 W=2.08e-05 rf_flag=0
M64 PAD 7 VDDO VMAX P5 L=5e-07 W=2.08e-05 rf_flag=0
M65 VDDO 7 PAD VMAX P5 L=5e-07 W=2.08e-05 rf_flag=0
M66 VMAX PADR VDDO VMAX P5 L=5e-07 W=1e-05 rf_flag=0
M67 VDDO PADR VMAX VMAX P5 L=5e-07 W=1e-05 rf_flag=0
M68 VMAX PADR VDDO VMAX P5 L=5e-07 W=1e-05 rf_flag=0
M69 PADR 13 VMAX VMAX P5 L=5e-07 W=1e-05 rf_flag=0
M70 VMAX 13 PADR VMAX P5 L=5e-07 W=1e-05 rf_flag=0
M71 PADR 13 VMAX VMAX P5 L=5e-07 W=1e-05 rf_flag=0
R72 VSSO 10 1016.12 L=7e-06 W=3e-06 postlayout=1 $SUB=VSSO $[RE3]
R73 VSSO 6 1016.12 L=7e-06 W=3e-06 postlayout=1 $SUB=VSSO $[RE3]
R74 13 VDDO 1016.12 L=7e-06 W=3e-06 postlayout=1 $SUB=VSSO $[RE3]
R75 PADR PAD 1090.5 L=1.3e-05 W=5e-06 postlayout=1 $SUB=VSSO $[RE3]
R76 9 VMAX 1016.12 L=7e-06 W=3e-06 postlayout=1 $SUB=VSSO $[RE3]
R77 14 VMAX 1016.12 L=7e-06 W=3e-06 postlayout=1 $SUB=VSS $[RE3]
D78 VSS VMAX dwn2psub AREA=2.42956e-09 PJ=0.00022567
D79 VSSO VDDO dwn2psub AREA=3.11153e-09 PJ=0.00161948
D80 VSSO VDDO dwn2psub AREA=3.11153e-09 PJ=0.00161948
D81 VSS VDDO dwn2psub AREA=3.11153e-09 PJ=0.00161948
D82 VSS VDDO dwn2psub AREA=3.11153e-09 PJ=0.00161948
D83 VSS VDDO dwn2psub AREA=3.11153e-09 PJ=0.00161948
D84 VSSO VDDO dwn2psub AREA=3.11153e-09 PJ=0.00161948
D85 VSS VDDO dwn2psub AREA=3.11153e-09 PJ=0.00161948
D86 VSSO VSSO dwn2psub AREA=6.3709e-10 PJ=0.00010544
D87 VSS VSS dwn2psub AREA=6.3709e-10 PJ=0.00010544
D88 VSS VSSO dpnwcpl5 AREA=2.242e-11 PJ=3.25314e-05 nf=1
D89 VSS VSSO dpnwcpl5 AREA=2.242e-11 PJ=3.25314e-05 nf=1
D90 VSS VSSO dpnwcpl5 AREA=2.242e-11 PJ=3.25314e-05 nf=1
D91 VSS VSSO dpnwcpl5 AREA=2.242e-11 PJ=3.25314e-05 nf=1
D92 VSS VSSO dpnwcpl5 AREA=2.242e-11 PJ=3.25314e-05 nf=1
D93 VSS VSSO dpnwcpl5 AREA=2.242e-11 PJ=3.25314e-05 nf=1
D94 VSS VSSO dpnwcpl5 AREA=2.242e-11 PJ=3.25314e-05 nf=1
D95 VSSO VSS dpnwcpl5 AREA=2.242e-11 PJ=3.25314e-05 nf=1
D96 VSSO VSS dpnwcpl5 AREA=2.242e-11 PJ=3.25314e-05 nf=1
D97 VSSO VSS dpnwcpl5 AREA=2.242e-11 PJ=3.25314e-05 nf=1
D98 VSSO VSS dpnwcpl5 AREA=2.242e-11 PJ=3.25314e-05 nf=1
D99 VSSO VSS dpnwcpl5 AREA=2.242e-11 PJ=3.25314e-05 nf=1
D100 VSSO VSS dpnwcpl5 AREA=2.242e-11 PJ=3.25314e-05 nf=1
D101 VSSO VSS dpnwcpl5 AREA=2.242e-11 PJ=3.25314e-05 nf=1
.ENDS

.SUBCKT PAL_NA_18 PAD VDDO VSSO VSS VDD PADR
*.PININFO PAD:B VDDO:B VSSO:B VSS:B VDD:B PADR:B
M0 PAD 6 VSS VSS N L=2.5e-07 W=2.4e-05 rf_flag=0
M1 VSS 6 PAD VSS N L=2.5e-07 W=2.4e-05 rf_flag=0
M2 PAD 6 VSS VSS N L=2.5e-07 W=2.4e-05 rf_flag=0
M3 VSS 6 PAD VSS N L=2.5e-07 W=2.4e-05 rf_flag=0
M4 PAD 6 VSS VSS N L=2.5e-07 W=2.4e-05 rf_flag=0
M5 VSS 6 PAD VSS N L=2.5e-07 W=2.4e-05 rf_flag=0
M6 PAD 6 VSS VSS N L=2.5e-07 W=2.4e-05 rf_flag=0
M7 VSS 6 PAD VSS N L=2.5e-07 W=2.4e-05 rf_flag=0
M8 PAD 6 VSS VSS N L=2.5e-07 W=2.4e-05 rf_flag=0
M9 VSS 6 PAD VSS N L=2.5e-07 W=2.4e-05 rf_flag=0
M10 PAD 6 VSS VSS N L=2.5e-07 W=2.4e-05 rf_flag=0
M11 VSS 6 PAD VSS N L=2.5e-07 W=2.4e-05 rf_flag=0
M12 PAD 6 VSS VSS N L=2.5e-07 W=2.4e-05 rf_flag=0
M13 VSS 6 PAD VSS N L=2.5e-07 W=2.4e-05 rf_flag=0
M14 PAD 6 VSS VSS N L=2.5e-07 W=2.4e-05 rf_flag=0
M15 VSS 6 PAD VSS N L=2.5e-07 W=2.4e-05 rf_flag=0
M16 VSS 7 6 VSS N L=1.8e-07 W=2e-05 rf_flag=0
M17 PADR 10 VSS VSS N L=2.5e-07 W=2e-05 rf_flag=0
M18 VSS 10 PADR VSS N L=2.5e-07 W=2e-05 rf_flag=0
M19 PAD 14 VSSO VSSO N L=2.5e-07 W=2.4e-05 rf_flag=0
M20 VSSO 14 PAD VSSO N L=2.5e-07 W=2.4e-05 rf_flag=0
M21 PAD 14 VSSO VSSO N L=2.5e-07 W=2.4e-05 rf_flag=0
M22 VSSO 14 PAD VSSO N L=2.5e-07 W=2.4e-05 rf_flag=0
M23 PAD 14 VSSO VSSO N L=2.5e-07 W=2.4e-05 rf_flag=0
M24 VSSO 14 PAD VSSO N L=2.5e-07 W=2.4e-05 rf_flag=0
M25 PAD 14 VSSO VSSO N L=2.5e-07 W=2.4e-05 rf_flag=0
M26 VSSO 14 PAD VSSO N L=2.5e-07 W=2.4e-05 rf_flag=0
M27 PAD 14 VSSO VSSO N L=2.5e-07 W=2.4e-05 rf_flag=0
M28 VSSO 14 PAD VSSO N L=2.5e-07 W=2.4e-05 rf_flag=0
M29 PAD 14 VSSO VSSO N L=2.5e-07 W=2.4e-05 rf_flag=0
M30 VSSO 14 PAD VSSO N L=2.5e-07 W=2.4e-05 rf_flag=0
M31 PAD 14 VSSO VSSO N L=2.5e-07 W=2.4e-05 rf_flag=0
M32 VSSO 14 PAD VSSO N L=2.5e-07 W=2.4e-05 rf_flag=0
M33 PAD 14 VSSO VSSO N L=2.5e-07 W=2.4e-05 rf_flag=0
M34 VSSO 14 PAD VSSO N L=2.5e-07 W=2.4e-05 rf_flag=0
M35 VSSO 12 14 VSSO N L=1.8e-07 W=2e-05 rf_flag=0
M36 PAD 15 VDD VMAX P L=2.5e-07 W=2.08e-05 rf_flag=0
M37 VDD 15 PAD VMAX P L=2.5e-07 W=2.08e-05 rf_flag=0
M38 PAD 15 VDD VMAX P L=2.5e-07 W=2.08e-05 rf_flag=0
M39 VDD 15 PAD VMAX P L=2.5e-07 W=2.08e-05 rf_flag=0
M40 PAD 15 VDD VMAX P L=2.5e-07 W=2.08e-05 rf_flag=0
M41 VDD 15 PAD VMAX P L=2.5e-07 W=2.08e-05 rf_flag=0
M42 PAD 15 VDD VMAX P L=2.5e-07 W=2.08e-05 rf_flag=0
M43 VDD 15 PAD VMAX P L=2.5e-07 W=2.08e-05 rf_flag=0
M44 PAD 15 VDD VMAX P L=2.5e-07 W=2.08e-05 rf_flag=0
M45 VDD 15 PAD VMAX P L=2.5e-07 W=2.08e-05 rf_flag=0
M46 PAD 15 VDD VMAX P L=2.5e-07 W=2.08e-05 rf_flag=0
M47 VDD 15 PAD VMAX P L=2.5e-07 W=2.08e-05 rf_flag=0
M48 PAD 15 VDD VMAX P L=2.5e-07 W=2.08e-05 rf_flag=0
M49 VDD 15 PAD VMAX P L=2.5e-07 W=2.08e-05 rf_flag=0
M50 PAD 15 VDD VMAX P L=2.5e-07 W=2.08e-05 rf_flag=0
M51 VDD 15 PAD VMAX P L=2.5e-07 W=2.08e-05 rf_flag=0
M52 PAD 15 VDD VMAX P L=2.5e-07 W=2.08e-05 rf_flag=0
M53 VDD 15 PAD VMAX P L=2.5e-07 W=2.08e-05 rf_flag=0
M54 PAD 15 VDD VMAX P L=2.5e-07 W=2.08e-05 rf_flag=0
M55 VDD 15 PAD VMAX P L=2.5e-07 W=2.08e-05 rf_flag=0
M56 PADR 13 VMAX VMAX P L=1.8e-07 W=1.5e-05 rf_flag=0
M57 VMAX 13 PADR VMAX P L=1.8e-07 W=1.5e-05 rf_flag=0
M58 VDD PADR VMAX VMAX P L=1.8e-07 W=1.5e-05 rf_flag=0
M59 VMAX PADR VDD VMAX P L=1.8e-07 W=1.5e-05 rf_flag=0
M60 15 9 VMAX VMAX P L=1.8e-07 W=1.5e-05 rf_flag=0
M61 VMAX 9 15 VMAX P L=1.8e-07 W=1.5e-05 rf_flag=0
M62 VMAX VMAX VDD VMAX P L=1.8e-07 W=1e-05 rf_flag=0
R63 7 VMAX 1016.12 L=7e-06 W=3e-06 postlayout=1 $SUB=VSS $[RE3]
R64 VSS 9 1016.12 L=7e-06 W=3e-06 postlayout=1 $SUB=VSS $[RE3]
R65 VSS 10 1016.12 L=7e-06 W=3e-06 postlayout=1 $SUB=VSS $[RE3]
R66 PADR PAD 1090.5 L=1.3e-05 W=5e-06 postlayout=1 $SUB=VSS $[RE3]
R67 12 VMAX 1016.12 L=7e-06 W=3e-06 postlayout=1 $SUB=VSSO $[RE3]
R68 VDD 13 1016.12 L=7e-06 W=3e-06 postlayout=1 $SUB=VSSO $[RE3]
D69 VSS VDD dwn2psub AREA=2.60522e-09 PJ=0.00149607
D70 VSSO VDD dwn2psub AREA=2.60522e-09 PJ=0.00149607
D71 VSS VDD dwn2psub AREA=2.60522e-09 PJ=0.00149607
D72 VSS VDD dwn2psub AREA=2.60522e-09 PJ=0.00149607
D73 VSSO VSS dwn2psub AREA=6.3709e-10 PJ=0.00010544
D74 VSS VSSO dwn2psub AREA=6.3709e-10 PJ=0.00010544
D75 VSSO VDD dwn2psub AREA=2.60522e-09 PJ=0.00149607
D76 VSSO VDD dwn2psub AREA=2.60522e-09 PJ=0.00149607
D77 VSS VMAX dwn2psub AREA=2.32217e-09 PJ=0.00021815
D78 VSS VDD dwn2psub AREA=2.60522e-09 PJ=0.00149607
D79 VSSO VSS dpnwcpl18 AREA=2.242e-11 PJ=3.25314e-05 nf=1
D80 VSSO VSS dpnwcpl18 AREA=2.242e-11 PJ=3.25314e-05 nf=1
D81 VSSO VSS dpnwcpl18 AREA=2.242e-11 PJ=3.25314e-05 nf=1
D82 VSSO VSS dpnwcpl18 AREA=2.242e-11 PJ=3.25314e-05 nf=1
D83 VSSO VSS dpnwcpl18 AREA=2.242e-11 PJ=3.25314e-05 nf=1
D84 VSSO VSS dpnwcpl18 AREA=2.242e-11 PJ=3.25314e-05 nf=1
D85 VSSO VSS dpnwcpl18 AREA=2.242e-11 PJ=3.25314e-05 nf=1
D86 VSS VSSO dpnwcpl18 AREA=2.242e-11 PJ=3.25314e-05 nf=1
D87 VSS VSSO dpnwcpl18 AREA=2.242e-11 PJ=3.25314e-05 nf=1
D88 VSS VSSO dpnwcpl18 AREA=2.242e-11 PJ=3.25314e-05 nf=1
D89 VSS VSSO dpnwcpl18 AREA=2.242e-11 PJ=3.25314e-05 nf=1
D90 VSS VSSO dpnwcpl18 AREA=2.242e-11 PJ=3.25314e-05 nf=1
D91 VSS VSSO dpnwcpl18 AREA=2.242e-11 PJ=3.25314e-05 nf=1
D92 VSS VSSO dpnwcpl18 AREA=2.242e-11 PJ=3.25314e-05 nf=1
.ENDS

.SUBCKT PAN_50_NA PAD VDDO VSS VDD VSSO PADR
*.PININFO PAD:B VDDO:B VSS:B VDD:B VSSO:B PADR:B
M0 VSSO 8 PAD PAD N5_ISO L=6e-07 W=2.4e-05 rf_flag=0
M1 PAD 8 VSSO PAD N5_ISO L=6e-07 W=2.4e-05 rf_flag=0
M2 VSSO 8 PAD PAD N5_ISO L=6e-07 W=2.4e-05 rf_flag=0
M3 PAD 8 VSSO PAD N5_ISO L=6e-07 W=2.4e-05 rf_flag=0
M4 VSSO 8 PAD PAD N5_ISO L=6e-07 W=2.4e-05 rf_flag=0
M5 PAD 8 VSSO PAD N5_ISO L=6e-07 W=2.4e-05 rf_flag=0
M6 VSSO 8 PAD PAD N5_ISO L=6e-07 W=2.4e-05 rf_flag=0
M7 PAD 8 VSSO PAD N5_ISO L=6e-07 W=2.4e-05 rf_flag=0
M8 VSSO 8 PAD PAD N5_ISO L=6e-07 W=2.4e-05 rf_flag=0
M9 PAD 8 VSSO PAD N5_ISO L=6e-07 W=2.4e-05 rf_flag=0
M10 VSSO 8 PAD PAD N5_ISO L=6e-07 W=2.4e-05 rf_flag=0
M11 PAD 8 VSSO PAD N5_ISO L=6e-07 W=2.4e-05 rf_flag=0
M12 VSSO 8 PAD PAD N5_ISO L=6e-07 W=2.4e-05 rf_flag=0
M13 PAD 8 VSSO PAD N5_ISO L=6e-07 W=2.4e-05 rf_flag=0
M14 VSSO 8 PAD PAD N5_ISO L=6e-07 W=2.4e-05 rf_flag=0
M15 PAD 8 VSSO PAD N5_ISO L=6e-07 W=2.4e-05 rf_flag=0
M16 VSS 9 PAD PAD N5_ISO L=6e-07 W=2.4e-05 rf_flag=0
M17 PAD 9 VSS PAD N5_ISO L=6e-07 W=2.4e-05 rf_flag=0
M18 VSS 9 PAD PAD N5_ISO L=6e-07 W=2.4e-05 rf_flag=0
M19 PAD 9 VSS PAD N5_ISO L=6e-07 W=2.4e-05 rf_flag=0
M20 VSS 9 PAD PAD N5_ISO L=6e-07 W=2.4e-05 rf_flag=0
M21 PAD 9 VSS PAD N5_ISO L=6e-07 W=2.4e-05 rf_flag=0
M22 VSS 9 PAD PAD N5_ISO L=6e-07 W=2.4e-05 rf_flag=0
M23 PAD 9 VSS PAD N5_ISO L=6e-07 W=2.4e-05 rf_flag=0
M24 VSS 9 PAD PAD N5_ISO L=6e-07 W=2.4e-05 rf_flag=0
M25 PAD 9 VSS PAD N5_ISO L=6e-07 W=2.4e-05 rf_flag=0
M26 VSS 9 PAD PAD N5_ISO L=6e-07 W=2.4e-05 rf_flag=0
M27 PAD 9 VSS PAD N5_ISO L=6e-07 W=2.4e-05 rf_flag=0
M28 VSS 9 PAD PAD N5_ISO L=6e-07 W=2.4e-05 rf_flag=0
M29 PAD 9 VSS PAD N5_ISO L=6e-07 W=2.4e-05 rf_flag=0
M30 VSS 9 PAD PAD N5_ISO L=6e-07 W=2.4e-05 rf_flag=0
M31 PAD 9 VSS PAD N5_ISO L=6e-07 W=2.4e-05 rf_flag=0
M32 VSSO 12 PADR PADR N5_ISO L=6e-07 W=2e-05 rf_flag=0
M33 PADR 12 VSSO PADR N5_ISO L=6e-07 W=2e-05 rf_flag=0
M34 VSS 10 PADR PADR N5_ISO L=6e-07 W=2e-05 rf_flag=0
M35 PADR 10 VSS PADR N5_ISO L=6e-07 W=2e-05 rf_flag=0
R36 7 VSS 1016.12 L=7e-06 W=3e-06 postlayout=1 $SUB=VSS $[RE3]
R37 PAD 9 8325.14 L=4e-05 W=2e-06 postlayout=1 $SUB=VSSO $[RE3]
R38 10 PADR 8325.14 L=4e-05 W=2e-06 postlayout=1 $SUB=VSSO $[RE3]
R39 PAD 8 8325.14 L=4e-05 W=2e-06 postlayout=1 $SUB=VSSO $[RE3]
R40 12 PADR 8325.14 L=4e-05 W=2e-06 postlayout=1 $SUB=VSSO $[RE3]
R41 VSSO 6 1016.12 L=7e-06 W=3e-06 postlayout=1 $SUB=VSSO $[RE3]
R42 PAD PADR 1090.5 L=1.3e-05 W=5e-06 postlayout=1 $SUB=VSSO $[RE3]
D43 PAD VDDO DDWNPW18 AREA=2.63784e-09 PJ=0.00022976
D44 PAD VDDO DDWNPW18 AREA=8.13555e-09 PJ=0.00038855
D45 PAD VDDO DDWNPW18 AREA=2.63784e-09 PJ=0.00022976
D46 VSS VDDO DDWNPW18 AREA=2.002e-10 PJ=6.74e-05
D47 VSS VDDO DDWNPW18 AREA=1.11214e-09 PJ=0.00014804
D48 VSSO VDDO DDWNPW18 AREA=1.11214e-09 PJ=0.00014804
D49 VSSO VDDO DDWNPW18 AREA=2.11656e-09 PJ=0.00027241
D50 PADR VDDO DDWNPW18 AREA=2.44322e-10 PJ=7.02e-05
D51 VSS VDDO DDWNPS18 AREA=2.15322e-08 PJ=0.00064331
M52 13 PAD PAD PAD n59pcesd L=6e-07 W=4.8e-05
M53 VDDO 6 13 PAD n59pcesd L=6e-07 W=4.8e-05
M54 14 6 VDDO PAD n59pcesd L=6e-07 W=4.8e-05
M55 PAD PAD 14 PAD n59pcesd L=6e-07 W=4.8e-05
M56 15 PAD PAD PAD n59pcesd L=6e-07 W=4.8e-05
M57 VDDO 6 15 PAD n59pcesd L=6e-07 W=4.8e-05
M58 16 6 VDDO PAD n59pcesd L=6e-07 W=4.8e-05
M59 PAD PAD 16 PAD n59pcesd L=6e-07 W=4.8e-05
M60 17 PAD PAD PAD n59pcesd L=6e-07 W=4.8e-05
M61 VDDO 6 17 PAD n59pcesd L=6e-07 W=4.8e-05
M62 18 6 VDDO PAD n59pcesd L=6e-07 W=4.8e-05
M63 PAD PAD 18 PAD n59pcesd L=6e-07 W=4.8e-05
M64 19 PAD PAD PAD n59pcesd L=6e-07 W=4.8e-05
M65 VDDO 6 19 PAD n59pcesd L=6e-07 W=4.8e-05
M66 20 6 VDDO PAD n59pcesd L=6e-07 W=4.8e-05
M67 PAD PAD 20 PAD n59pcesd L=6e-07 W=4.8e-05
M68 21 PAD PAD PAD n59pcesd L=6e-07 W=4.8e-05
M69 VDDO 6 21 PAD n59pcesd L=6e-07 W=4.8e-05
M70 22 6 VDDO PAD n59pcesd L=6e-07 W=4.8e-05
M71 PAD PAD 22 PAD n59pcesd L=6e-07 W=4.8e-05
M72 23 PAD PAD PAD n59pcesd L=6e-07 W=4.8e-05
M73 VDD 7 23 PAD n59pcesd L=6e-07 W=4.8e-05
M74 24 7 VDD PAD n59pcesd L=6e-07 W=4.8e-05
M75 PAD PAD 24 PAD n59pcesd L=6e-07 W=4.8e-05
M76 25 PAD PAD PAD n59pcesd L=6e-07 W=4.8e-05
M77 VDD 7 25 PAD n59pcesd L=6e-07 W=4.8e-05
M78 26 7 VDD PAD n59pcesd L=6e-07 W=4.8e-05
M79 PAD PAD 26 PAD n59pcesd L=6e-07 W=4.8e-05
M80 27 PAD PAD PAD n59pcesd L=6e-07 W=4.8e-05
M81 VDD 7 27 PAD n59pcesd L=6e-07 W=4.8e-05
M82 28 7 VDD PAD n59pcesd L=6e-07 W=4.8e-05
M83 PAD PAD 28 PAD n59pcesd L=6e-07 W=4.8e-05
M84 29 PAD PAD PAD n59pcesd L=6e-07 W=4.8e-05
M85 VDD 7 29 PAD n59pcesd L=6e-07 W=4.8e-05
M86 30 7 VDD PAD n59pcesd L=6e-07 W=4.8e-05
M87 PAD PAD 30 PAD n59pcesd L=6e-07 W=4.8e-05
M88 31 PAD PAD PAD n59pcesd L=6e-07 W=4.8e-05
M89 VDD 7 31 PAD n59pcesd L=6e-07 W=4.8e-05
M90 32 7 VDD PAD n59pcesd L=6e-07 W=4.8e-05
M91 PAD PAD 32 PAD n59pcesd L=6e-07 W=4.8e-05
D92 VSS VSSO dnpwcpl5 AREA=1.492e-11 PJ=2.25314e-05 nf=1
D93 VSS VSSO dnpwcpl5 AREA=1.492e-11 PJ=2.25314e-05 nf=1
D94 VSS VSSO dnpwcpl5 AREA=1.492e-11 PJ=2.25314e-05 nf=1
D95 VSS VSSO dnpwcpl5 AREA=1.492e-11 PJ=2.25314e-05 nf=1
D96 VSS VSSO dnpwcpl5 AREA=1.492e-11 PJ=2.25314e-05 nf=1
D97 VSS VSSO dnpwcpl5 AREA=1.492e-11 PJ=2.25314e-05 nf=1
D98 VSS VSSO dnpwcpl5 AREA=1.492e-11 PJ=2.25314e-05 nf=1
D99 VSS VSSO dnpwcpl5 AREA=1.492e-11 PJ=2.25314e-05 nf=1
D100 VSS VSSO dnpwcpl5 AREA=1.492e-11 PJ=2.25314e-05 nf=1
D101 VSS VSSO dnpwcpl5 AREA=1.492e-11 PJ=2.25314e-05 nf=1
D102 VSSO VSS dnpwcpl5 AREA=1.492e-11 PJ=2.25314e-05 nf=1
D103 VSSO VSS dnpwcpl5 AREA=1.492e-11 PJ=2.25314e-05 nf=1
D104 VSSO VSS dnpwcpl5 AREA=1.492e-11 PJ=2.25314e-05 nf=1
D105 VSSO VSS dnpwcpl5 AREA=1.492e-11 PJ=2.25314e-05 nf=1
D106 VSSO VSS dnpwcpl5 AREA=1.492e-11 PJ=2.25314e-05 nf=1
D107 VSSO VSS dnpwcpl5 AREA=1.492e-11 PJ=2.25314e-05 nf=1
D108 VSSO VSS dnpwcpl5 AREA=1.492e-11 PJ=2.25314e-05 nf=1
D109 VSSO VSS dnpwcpl5 AREA=1.492e-11 PJ=2.25314e-05 nf=1
D110 VSSO VSS dnpwcpl5 AREA=1.492e-11 PJ=2.25314e-05 nf=1
D111 VSSO VSS dnpwcpl5 AREA=1.492e-11 PJ=2.25314e-05 nf=1
.ENDS

.SUBCKT PIOH_18_18 PAD VSSO VSS VDD VDDO SCHM_ON EN IE VDDO_OK I PULL_UP_DOWN PULL_ON TTL_ON DRIVE_STR VDD_OK CIN
*.PININFO PAD:B VSSO:B VSS:B VDD:B VDDO:B SCHM_ON:I EN:I IE:I VDDO_OK:I I:I PULL_UP_DOWN:I PULL_ON:I TTL_ON:I DRIVE_STR:I VDD_OK:I CIN:O
M0 78 VDDO_OK 7 VSSO N L=1.8e-07 W=5e-06 rf_flag=0
M1 7 VDDO_OK 78 VSSO N L=1.8e-07 W=5e-06 rf_flag=0
M2 78 VDDO_OK 7 VSSO N L=1.8e-07 W=5e-06 rf_flag=0
M3 7 VDDO_OK 78 VSSO N L=1.8e-07 W=5e-06 rf_flag=0
M4 78 8 VSSO VSSO N L=1.8e-07 W=5e-06 rf_flag=0
M5 VSSO 8 78 VSSO N L=1.8e-07 W=5e-06 rf_flag=0
M6 78 8 VSSO VSSO N L=1.8e-07 W=5e-06 rf_flag=0
M7 VSSO 8 78 VSSO N L=1.8e-07 W=5e-06 rf_flag=0
M8 37 7 VSSO VSSO N L=1.8e-07 W=5e-06 rf_flag=0
M9 VSSO 7 37 VSSO N L=1.8e-07 W=5e-06 rf_flag=0
M10 37 7 VSSO VSSO N L=1.8e-07 W=5e-06 rf_flag=0
M11 VSS SCHM_ON 8 VSS N L=1.8e-07 W=2.5e-06 rf_flag=0
M12 25 IE VSSO VSSO N L=1.8e-07 W=6.5e-06 rf_flag=0
M13 VSSO IE 25 VSSO N L=1.8e-07 W=6.5e-06 rf_flag=0
M14 13 VDDO_OK VSSO VSSO N L=1.8e-07 W=3.75e-06 rf_flag=0
M15 VSSO VDDO_OK 13 VSSO N L=1.8e-07 W=3.75e-06 rf_flag=0
M16 11 SCHM_ON VSSO VSSO N L=1.8e-07 W=4.34e-06 rf_flag=0
M17 VSSO SCHM_ON 11 VSSO N L=1.8e-07 W=4.34e-06 rf_flag=0
M18 11 SCHM_ON VSSO VSSO N L=1.8e-07 W=4.34e-06 rf_flag=0
M19 8 SCHM_ON VSS VSS N L=1.8e-07 W=2.5e-06 rf_flag=0
M20 17 VMAX VSSO VSSO N L=3e-06 W=5e-06 rf_flag=0
M21 20 IE VSS VSS N L=1.8e-07 W=2.5e-06 rf_flag=0
M22 VSSO 19 18 VSSO N L=1.8e-07 W=3e-06 rf_flag=0
M23 19 VDDO_OK VSSO VSSO N L=1.8e-07 W=3e-06 rf_flag=0
M24 80 24 VSSO VSSO N L=1.8e-07 W=5e-06 rf_flag=0
M25 VSSO 24 80 VSSO N L=1.8e-07 W=5e-06 rf_flag=0
M26 80 24 VSSO VSSO N L=1.8e-07 W=5e-06 rf_flag=0
M27 VSSO 24 80 VSSO N L=1.8e-07 W=5e-06 rf_flag=0
M28 21 EN VSSO VSSO N L=1.8e-07 W=4.5e-06 rf_flag=0
M29 VSSO EN 21 VSSO N L=1.8e-07 W=4.5e-06 rf_flag=0
M30 34 18 VSSO VSSO N L=1.8e-07 W=5e-06 rf_flag=0
M31 VSSO 18 34 VSSO N L=1.8e-07 W=5e-06 rf_flag=0
M32 34 18 VSSO VSSO N L=1.8e-07 W=5e-06 rf_flag=0
M33 80 VDDO_OK 18 VSSO N L=1.8e-07 W=5e-06 rf_flag=0
M34 18 VDDO_OK 80 VSSO N L=1.8e-07 W=5e-06 rf_flag=0
M35 80 VDDO_OK 18 VSSO N L=1.8e-07 W=5e-06 rf_flag=0
M36 18 VDDO_OK 80 VSSO N L=1.8e-07 W=5e-06 rf_flag=0
M37 VSS IE 20 VSS N L=1.8e-07 W=2.5e-06 rf_flag=0
M38 VSS EN 24 VSS N L=1.8e-07 W=2.5e-06 rf_flag=0
M39 30 20 VSSO VSSO N L=1.8e-07 W=5e-06 rf_flag=0
M40 VSSO 20 30 VSSO N L=1.8e-07 W=5e-06 rf_flag=0
M41 24 EN VSS VSS N L=1.8e-07 W=2.5e-06 rf_flag=0
M42 PAD 17 VSSO VSSO N L=2.5e-07 W=2.4e-05 rf_flag=0
M43 VSSO 14 PAD VSSO N L=2.5e-07 W=2.4e-05 rf_flag=0
M44 PAD 17 VSSO VSSO N L=2.5e-07 W=2.4e-05 rf_flag=0
M45 VSSO 14 PAD VSSO N L=2.5e-07 W=2.4e-05 rf_flag=0
M46 PAD 17 VSSO VSSO N L=2.5e-07 W=2.4e-05 rf_flag=0
M47 VSSO 14 PAD VSSO N L=2.5e-07 W=2.4e-05 rf_flag=0
M48 PAD 17 VSSO VSSO N L=2.5e-07 W=2.4e-05 rf_flag=0
M49 VSSO 15 PAD VSSO N L=2.5e-07 W=2.4e-05 rf_flag=0
M50 PAD 17 VSSO VSSO N L=2.5e-07 W=2.4e-05 rf_flag=0
M51 VSSO 15 PAD VSSO N L=2.5e-07 W=2.4e-05 rf_flag=0
M52 PAD 17 VSSO VSSO N L=2.5e-07 W=2.4e-05 rf_flag=0
M53 VSSO 15 PAD VSSO N L=2.5e-07 W=2.4e-05 rf_flag=0
M54 PAD 17 VSSO VSSO N L=2.5e-07 W=2.4e-05 rf_flag=0
M55 VSSO 16 PAD VSSO N L=2.5e-07 W=2.4e-05 rf_flag=0
M56 PAD 17 VSSO VSSO N L=2.5e-07 W=2.4e-05 rf_flag=0
M57 VSSO 16 PAD VSSO N L=2.5e-07 W=2.4e-05 rf_flag=0
M58 30 13 VSSO VSSO N L=1.8e-07 W=2e-06 rf_flag=0
M59 VSSO 31 55 VSSO N L=1.8e-07 W=1e-05 rf_flag=0
M60 55 31 VSSO VSSO N L=1.8e-07 W=1e-05 rf_flag=0
M61 VSS EN 24 VSS N L=1.8e-07 W=2.5e-06 rf_flag=0
M62 VSSO 22 55 VSSO N L=8e-06 W=1.5e-06 rf_flag=0
M63 52 32 VSSO VSSO N L=1.8e-07 W=1e-05 rf_flag=0
M64 VSSO 32 52 VSSO N L=1.8e-07 W=1e-05 rf_flag=0
M65 52 32 VSSO VSSO N L=1.8e-07 W=1e-05 rf_flag=0
M66 24 EN VSS VSS N L=1.8e-07 W=2.5e-06 rf_flag=0
M67 81 VDDO_OK 26 VSSO N L=1.8e-07 W=5e-06 rf_flag=0
M68 26 VDDO_OK 81 VSSO N L=1.8e-07 W=5e-06 rf_flag=0
M69 81 VDDO_OK 26 VSSO N L=1.8e-07 W=5e-06 rf_flag=0
M70 26 VDDO_OK 81 VSSO N L=1.8e-07 W=5e-06 rf_flag=0
M71 81 27 VSSO VSSO N L=1.8e-07 W=5e-06 rf_flag=0
M72 VSSO 27 81 VSSO N L=1.8e-07 W=5e-06 rf_flag=0
M73 81 27 VSSO VSSO N L=1.8e-07 W=5e-06 rf_flag=0
M74 VSSO 27 81 VSSO N L=1.8e-07 W=5e-06 rf_flag=0
M75 35 26 VSSO VSSO N L=1.8e-07 W=5e-06 rf_flag=0
M76 VSSO 26 35 VSSO N L=1.8e-07 W=5e-06 rf_flag=0
M77 35 26 VSSO VSSO N L=1.8e-07 W=5e-06 rf_flag=0
M78 VSS I 27 VSS N L=1.8e-07 W=2.5e-06 rf_flag=0
M79 29 I VSSO VSSO N L=1.8e-07 W=4.5e-06 rf_flag=0
M80 VSSO I 29 VSSO N L=1.8e-07 W=4.5e-06 rf_flag=0
M81 27 I VSS VSS N L=1.8e-07 W=2.5e-06 rf_flag=0
M82 54 30 VSSO VSSO N L=1.8e-07 W=3.75e-06 rf_flag=0
M83 VSSO 30 54 VSSO N L=1.8e-07 W=3.75e-06 rf_flag=0
M84 VSS I 27 VSS N L=1.8e-07 W=2.5e-06 rf_flag=0
M85 27 I VSS VSS N L=1.8e-07 W=2.5e-06 rf_flag=0
M86 VSS PULL_UP_DOWN 22 VSS N L=1.8e-07 W=3.75e-06 rf_flag=0
M87 VSSO 46 14 VSSO N L=1.8e-07 W=1.5e-05 rf_flag=0
M88 14 46 VSSO VSSO N L=1.8e-07 W=1.5e-05 rf_flag=0
M89 22 PULL_UP_DOWN VSS VSS N L=1.8e-07 W=3.75e-06 rf_flag=0
M90 VSSO 36 32 VSSO N L=1.8e-07 W=5e-06 rf_flag=0
M91 32 36 VSSO VSSO N L=1.8e-07 W=5e-06 rf_flag=0
M92 VSSO 36 32 VSSO N L=1.8e-07 W=5e-06 rf_flag=0
M93 32 35 VSSO VSSO N L=1.8e-07 W=5e-06 rf_flag=0
M94 VSSO 35 32 VSSO N L=1.8e-07 W=5e-06 rf_flag=0
M95 32 35 VSSO VSSO N L=1.8e-07 W=5e-06 rf_flag=0
M96 VSSO 34 32 VSSO N L=1.8e-07 W=5e-06 rf_flag=0
M97 32 34 VSSO VSSO N L=1.8e-07 W=5e-06 rf_flag=0
M98 VSSO 34 32 VSSO N L=1.8e-07 W=5e-06 rf_flag=0
M99 VSS PULL_UP_DOWN 22 VSS N L=1.8e-07 W=3.75e-06 rf_flag=0
M100 22 PULL_UP_DOWN VSS VSS N L=1.8e-07 W=3.75e-06 rf_flag=0
M101 75 43 74 VSSO N L=1.8e-07 W=1e-05 rf_flag=0
M102 74 43 75 VSSO N L=1.8e-07 W=1e-05 rf_flag=0
M103 75 43 74 VSSO N L=1.8e-07 W=1e-05 rf_flag=0
M104 52 32 75 VSSO N L=1.8e-07 W=1e-05 rf_flag=0
M105 75 32 52 VSSO N L=1.8e-07 W=1e-05 rf_flag=0
M106 52 32 75 VSSO N L=1.8e-07 W=1e-05 rf_flag=0
M107 VSS 38 22 VSS N L=1.8e-07 W=3.75e-06 rf_flag=0
M108 22 38 VSS VSS N L=1.8e-07 W=3.75e-06 rf_flag=0
M109 VSS 38 22 VSS N L=1.8e-07 W=3.75e-06 rf_flag=0
M110 VSSO 42 36 VSSO N L=1.8e-07 W=5e-06 rf_flag=0
M111 36 42 VSSO VSSO N L=1.8e-07 W=5e-06 rf_flag=0
M112 VSSO 47 16 VSSO N L=1.8e-07 W=7.5e-06 rf_flag=0
M113 16 47 VSSO VSSO N L=1.8e-07 W=7.5e-06 rf_flag=0
M114 VSSO 47 15 VSSO N L=1.8e-07 W=7.5e-06 rf_flag=0
M115 15 47 VSSO VSSO N L=1.8e-07 W=7.5e-06 rf_flag=0
M116 22 38 VSS VSS N L=1.8e-07 W=3.75e-06 rf_flag=0
M117 VSSO 37 40 VSSO N L=1.8e-07 W=5e-06 rf_flag=0
M118 39 44 VSSO VSSO N L=1.8e-07 W=5e-06 rf_flag=0
M119 38 PULL_ON VSS VSS N L=1.8e-07 W=3.5e-06 rf_flag=0
M120 85 39 VSSO VSSO N L=1.8e-07 W=2e-06 rf_flag=0
M121 44 40 85 VSSO N L=1.8e-07 W=1.3e-06 rf_flag=0
M122 VSS PULL_ON 38 VSS N L=1.8e-07 W=3.5e-06 rf_flag=0
M123 VSSO 16 42 VSSO N L=1.8e-07 W=5e-06 rf_flag=0
M124 64 50 VSSO VSSO N L=1.8e-07 W=1e-05 rf_flag=0
M125 44 TTL_ON 89 VSSO N L=1.8e-07 W=8.335e-06 rf_flag=0
M126 89 TTL_ON 44 VSSO N L=1.8e-07 W=8.335e-06 rf_flag=0
M127 44 TTL_ON 89 VSSO N L=1.8e-07 W=8.335e-06 rf_flag=0
M128 VSS PULL_ON 87 VSS N L=1.8e-07 W=3.5e-06 rf_flag=0
M129 87 PULL_ON VSS VSS N L=1.8e-07 W=3.5e-06 rf_flag=0
M130 68 PULL_UP_DOWN 87 VSS N L=1.8e-07 W=3.5e-06 rf_flag=0
M131 VSSO 49 43 VSSO N L=1.8e-07 W=1e-05 rf_flag=0
M132 43 49 VSSO VSSO N L=1.8e-07 W=1e-05 rf_flag=0
M133 87 PULL_UP_DOWN 68 VSS N L=1.8e-07 W=3.5e-06 rf_flag=0
M134 91 48 VSSO VSSO N L=1.8e-07 W=1e-05 rf_flag=0
M135 VSSO 48 91 VSSO N L=1.8e-07 W=1e-05 rf_flag=0
M136 91 55 89 VSSO N L=1.8e-07 W=8.335e-06 rf_flag=0
M137 89 55 91 VSSO N L=1.8e-07 W=8.335e-06 rf_flag=0
M138 91 55 89 VSSO N L=1.8e-07 W=8.335e-06 rf_flag=0
M139 VSSO 32 90 VSSO N L=1.8e-07 W=5e-06 rf_flag=0
M140 90 32 VSSO VSSO N L=1.8e-07 W=5e-06 rf_flag=0
M141 49 51 90 VSSO N L=1.8e-07 W=5e-06 rf_flag=0
M142 90 51 49 VSSO N L=1.8e-07 W=5e-06 rf_flag=0
M143 50 52 VSSO VSSO N L=1.8e-07 W=5e-06 rf_flag=0
M144 VSS DRIVE_STR 59 VSS N L=1.8e-07 W=5e-06 rf_flag=0
M145 44 55 91 VSSO N L=1.8e-07 W=5e-06 rf_flag=0
M146 59 DRIVE_STR VSS VSS N L=1.8e-07 W=5e-06 rf_flag=0
M147 CIN 56 VSS VSS N L=1.8e-07 W=5e-06 rf_flag=0
M148 VSS 56 CIN VSS N L=1.8e-07 W=5e-06 rf_flag=0
M149 92 63 VSSO VSSO N L=1.8e-07 W=1.5e-05 rf_flag=0
M150 93 35 92 VSSO N L=1.8e-07 W=1.5e-05 rf_flag=0
M151 47 64 93 VSSO N L=1.8e-07 W=1.5e-05 rf_flag=0
M152 CIN 56 VSS VSS N L=1.8e-07 W=5e-06 rf_flag=0
M153 95 VDDO_OK 58 VSSO N L=1.8e-07 W=5e-06 rf_flag=0
M154 58 VDDO_OK 95 VSSO N L=1.8e-07 W=5e-06 rf_flag=0
M155 95 VDDO_OK 58 VSSO N L=1.8e-07 W=5e-06 rf_flag=0
M156 58 VDDO_OK 95 VSSO N L=1.8e-07 W=5e-06 rf_flag=0
M157 95 59 VSSO VSSO N L=1.8e-07 W=5e-06 rf_flag=0
M158 VSSO 59 95 VSSO N L=1.8e-07 W=5e-06 rf_flag=0
M159 95 59 VSSO VSSO N L=1.8e-07 W=5e-06 rf_flag=0
M160 VSSO 59 95 VSSO N L=1.8e-07 W=5e-06 rf_flag=0
M161 71 58 VSSO VSSO N L=1.8e-07 W=5e-06 rf_flag=0
M162 VSSO 58 71 VSSO N L=1.8e-07 W=5e-06 rf_flag=0
M163 71 58 VSSO VSSO N L=1.8e-07 W=5e-06 rf_flag=0
M164 60 DRIVE_STR VSSO VSSO N L=1.8e-07 W=4.5e-06 rf_flag=0
M165 VSSO DRIVE_STR 60 VSSO N L=1.8e-07 W=4.5e-06 rf_flag=0
M166 48 54 VSSO VSSO N L=1.8e-07 W=3.75e-06 rf_flag=0
M167 VSSO 54 48 VSSO N L=1.8e-07 W=3.75e-06 rf_flag=0
M168 96 VDD_OK 56 VSS N L=1.8e-07 W=7e-06 rf_flag=0
M169 56 VDD_OK 96 VSS N L=1.8e-07 W=7e-06 rf_flag=0
M170 96 VDD_OK 56 VSS N L=1.8e-07 W=7e-06 rf_flag=0
M171 66 69 VSSO VSSO N L=1.8e-07 W=5e-06 rf_flag=0
M172 VSSO 69 66 VSSO N L=1.8e-07 W=5e-06 rf_flag=0
M173 66 69 VSSO VSSO N L=1.8e-07 W=5e-06 rf_flag=0
M174 VSSO 69 66 VSSO N L=1.8e-07 W=5e-06 rf_flag=0
M175 67 68 VSSO VSSO N L=1.8e-07 W=4.5e-06 rf_flag=0
M176 VSSO 68 67 VSSO N L=1.8e-07 W=4.5e-06 rf_flag=0
M177 62 66 VSSO VSSO N L=1.8e-07 W=5e-06 rf_flag=0
M178 VSSO 66 62 VSSO N L=1.8e-07 W=5e-06 rf_flag=0
M179 62 66 VSSO VSSO N L=1.8e-07 W=5e-06 rf_flag=0
M180 56 VDD_OK 96 VSS N L=1.8e-07 W=7e-06 rf_flag=0
M181 96 VDD_OK 56 VSS N L=1.8e-07 W=7e-06 rf_flag=0
M182 VSS 73 96 VSS N L=1.8e-07 W=7e-06 rf_flag=0
M183 96 73 VSS VSS N L=1.8e-07 W=7e-06 rf_flag=0
M184 VSS 73 96 VSS N L=1.8e-07 W=7e-06 rf_flag=0
M185 96 73 VSS VSS N L=1.8e-07 W=7e-06 rf_flag=0
M186 VSSO 62 61 VSSO N L=1.8e-07 W=5e-06 rf_flag=0
M187 73 44 VSSO VSSO N L=1.8e-07 W=5e-06 rf_flag=0
M188 VSSO 44 73 VSSO N L=1.8e-07 W=5e-06 rf_flag=0
M189 VSSO 71 51 VSSO N L=1.8e-07 W=7.5e-06 rf_flag=0
M190 51 71 VSSO VSSO N L=1.8e-07 W=7.5e-06 rf_flag=0
M191 VSSO 70 46 VSSO N L=1.8e-07 W=7.5e-06 rf_flag=0
M192 46 70 VSSO VSSO N L=1.8e-07 W=7.5e-06 rf_flag=0
M193 VSS 73 96 VSS N L=1.8e-07 W=7e-06 rf_flag=0
M194 VSSO 34 63 VSSO N L=1.8e-07 W=7.5e-06 rf_flag=0
M195 63 34 VSSO VSSO N L=1.8e-07 W=7.5e-06 rf_flag=0
M196 VSS 44 72 VSS N L=1.8e-07 W=4.5e-06 rf_flag=0
M197 70 71 VSSO VSSO N L=1.8e-07 W=5e-06 rf_flag=0
M198 VSSO 71 70 VSSO N L=1.8e-07 W=5e-06 rf_flag=0
M199 70 47 VSSO VSSO N L=1.8e-07 W=5e-06 rf_flag=0
M200 VSSO 47 70 VSSO N L=1.8e-07 W=5e-06 rf_flag=0
M201 77 63 VSSO VSSO N L=1.8e-07 W=5e-06 rf_flag=0
M202 VSSO 63 77 VSSO N L=1.8e-07 W=5e-06 rf_flag=0
M203 72 44 VSS VSS N L=1.8e-07 W=4.5e-06 rf_flag=0
M204 VSS 68 69 VSS N L=1.8e-07 W=5e-06 rf_flag=0
M205 69 68 VSS VSS N L=1.8e-07 W=5e-06 rf_flag=0
M206 VDD SCHM_ON 8 VDD P L=1.8e-07 W=2.5e-06 rf_flag=0
M207 13 VDDO_OK VDDO VDDO P L=1.8e-07 W=5e-06 rf_flag=0
M208 VDDO VDDO_OK 13 VDDO P L=1.8e-07 W=5e-06 rf_flag=0
M209 8 SCHM_ON VDD VDD P L=1.8e-07 W=2.5e-06 rf_flag=0
M210 37 7 VDDO VDDO P L=1.8e-07 W=5.01e-06 rf_flag=0
M211 VDDO 7 37 VDDO P L=1.8e-07 W=5.01e-06 rf_flag=0
M212 37 7 VDDO VDDO P L=1.8e-07 W=5.01e-06 rf_flag=0
M213 VDDO 7 37 VDDO P L=1.8e-07 W=5.01e-06 rf_flag=0
M214 VDD SCHM_ON 8 VDD P L=1.8e-07 W=2.5e-06 rf_flag=0
M215 8 SCHM_ON VDD VDD P L=1.8e-07 W=2.5e-06 rf_flag=0
M216 7 11 VDDO VDDO P L=1.8e-07 W=2.5e-06 rf_flag=0
M217 VDDO 11 7 VDDO P L=1.8e-07 W=2.5e-06 rf_flag=0
M218 7 VDDO_OK VDDO VDDO P L=1.8e-07 W=2.5e-06 rf_flag=0
M219 VDDO VDDO_OK 7 VDDO P L=1.8e-07 W=2.5e-06 rf_flag=0
M220 11 7 VDDO VDDO P L=1.8e-07 W=2e-06 rf_flag=0
M221 20 IE VDD VDD P L=1.8e-07 W=3.335e-06 rf_flag=0
M222 VDD IE 20 VDD P L=1.8e-07 W=3.335e-06 rf_flag=0
M223 18 21 VDDO VDDO P L=1.8e-07 W=2.5e-06 rf_flag=0
M224 VDDO 21 18 VDDO P L=1.8e-07 W=2.5e-06 rf_flag=0
M225 19 VDDO_OK VDDO VDDO P L=1.8e-07 W=2.5e-06 rf_flag=0
M226 VDDO VDDO_OK 19 VDDO P L=1.8e-07 W=2.5e-06 rf_flag=0
M227 21 18 VDDO VDDO P L=1.8e-07 W=2e-06 rf_flag=0
M228 34 18 VDDO VDDO P L=1.8e-07 W=5e-06 rf_flag=0
M229 VDDO 18 34 VDDO P L=1.8e-07 W=5e-06 rf_flag=0
M230 34 18 VDDO VDDO P L=1.8e-07 W=5e-06 rf_flag=0
M231 VDDO 18 34 VDDO P L=1.8e-07 W=5e-06 rf_flag=0
M232 79 25 30 VDDO P L=1.8e-07 W=5e-06 rf_flag=0
M233 VDDO 13 79 VDDO P L=1.8e-07 W=5e-06 rf_flag=0
M234 79 13 VDDO VDDO P L=1.8e-07 W=5e-06 rf_flag=0
M235 VDDO 13 79 VDDO P L=1.8e-07 W=5e-06 rf_flag=0
M236 20 IE VDD VDD P L=1.8e-07 W=3.335e-06 rf_flag=0
M237 VDD EN 24 VDD P L=1.8e-07 W=2.5e-06 rf_flag=0
M238 24 EN VDD VDD P L=1.8e-07 W=2.5e-06 rf_flag=0
M239 VDD EN 24 VDD P L=1.8e-07 W=2.5e-06 rf_flag=0
M240 24 EN VDD VDD P L=1.8e-07 W=2.5e-06 rf_flag=0
M241 VDDO 30 25 VDDO P L=1.8e-07 W=2e-06 rf_flag=0
M242 35 26 VDDO VDDO P L=1.8e-07 W=5e-06 rf_flag=0
M243 VDDO 26 35 VDDO P L=1.8e-07 W=5e-06 rf_flag=0
M244 35 26 VDDO VDDO P L=1.8e-07 W=5e-06 rf_flag=0
M245 VDDO 26 35 VDDO P L=1.8e-07 W=5e-06 rf_flag=0
M246 VDD I 27 VDD P L=1.8e-07 W=2.5e-06 rf_flag=0
M247 27 I VDD VDD P L=1.8e-07 W=2.5e-06 rf_flag=0
M248 26 29 VDDO VDDO P L=1.8e-07 W=2.5e-06 rf_flag=0
M249 VDDO 29 26 VDDO P L=1.8e-07 W=2.5e-06 rf_flag=0
M250 26 VDDO_OK VDDO VDDO P L=1.8e-07 W=2.5e-06 rf_flag=0
M251 VDDO VDDO_OK 26 VDDO P L=1.8e-07 W=2.5e-06 rf_flag=0
M252 54 30 VDDO VDDO P L=1.8e-07 W=5e-06 rf_flag=0
M253 VDDO 30 54 VDDO P L=1.8e-07 W=5e-06 rf_flag=0
M254 29 26 VDDO VDDO P L=1.8e-07 W=2e-06 rf_flag=0
M255 VDD I 27 VDD P L=1.8e-07 W=2.5e-06 rf_flag=0
M256 27 I VDD VDD P L=1.8e-07 W=2.5e-06 rf_flag=0
M257 22 PULL_UP_DOWN 84 VDD P L=1.8e-07 W=2e-06 rf_flag=0
M258 40 37 VDDO VDDO P L=1.8e-07 W=6e-06 rf_flag=0
M259 82 34 32 VDDO P L=1.8e-07 W=5e-06 rf_flag=0
M260 32 34 82 VDDO P L=1.8e-07 W=5e-06 rf_flag=0
M261 82 34 32 VDDO P L=1.8e-07 W=5e-06 rf_flag=0
M262 83 35 82 VDDO P L=1.8e-07 W=5e-06 rf_flag=0
M263 82 35 83 VDDO P L=1.8e-07 W=5e-06 rf_flag=0
M264 83 35 82 VDDO P L=1.8e-07 W=5e-06 rf_flag=0
M265 VDDO 36 83 VDDO P L=1.8e-07 W=5e-06 rf_flag=0
M266 83 36 VDDO VDDO P L=1.8e-07 W=5e-06 rf_flag=0
M267 VDDO 36 83 VDDO P L=1.8e-07 W=5e-06 rf_flag=0
M268 84 PULL_UP_DOWN 22 VDD P L=1.8e-07 W=2e-06 rf_flag=0
M269 22 PULL_UP_DOWN 84 VDD P L=1.8e-07 W=2e-06 rf_flag=0
M270 84 PULL_UP_DOWN 22 VDD P L=1.8e-07 W=2e-06 rf_flag=0
M271 VDD 38 84 VDD P L=1.8e-07 W=2e-06 rf_flag=0
M272 84 38 VDD VDD P L=1.8e-07 W=2e-06 rf_flag=0
M273 VDD 38 84 VDD P L=1.8e-07 W=2e-06 rf_flag=0
M274 84 38 VDD VDD P L=1.8e-07 W=2e-06 rf_flag=0
M275 15 46 14 VDDO P L=1.8e-07 W=1e-05 rf_flag=0
M276 14 46 15 VDDO P L=1.8e-07 W=1e-05 rf_flag=0
M277 15 46 14 VDDO P L=1.8e-07 W=1e-05 rf_flag=0
M278 16 47 15 VDDO P L=1.8e-07 W=1e-05 rf_flag=0
M279 15 47 16 VDDO P L=1.8e-07 W=1e-05 rf_flag=0
M280 16 47 15 VDDO P L=1.8e-07 W=1e-05 rf_flag=0
M281 VDDO 47 16 VDDO P L=1.8e-07 W=1e-05 rf_flag=0
M282 16 47 VDDO VDDO P L=1.8e-07 W=1e-05 rf_flag=0
M283 VDDO 47 16 VDDO P L=1.8e-07 W=1e-05 rf_flag=0
M284 VDDO 42 36 VDDO P L=1.8e-07 W=7.5e-06 rf_flag=0
M285 36 42 VDDO VDDO P L=1.8e-07 W=7.5e-06 rf_flag=0
M286 38 PULL_ON VDD VDD P L=1.8e-07 W=2.5e-06 rf_flag=0
M287 42 16 VDDO VDDO P L=1.8e-07 W=7.5e-06 rf_flag=0
M288 VDD PULL_ON 38 VDD P L=1.8e-07 W=2.5e-06 rf_flag=0
M289 VDDO 39 86 VDDO P L=1.8e-07 W=5e-06 rf_flag=0
M290 38 PULL_ON VDD VDD P L=1.8e-07 W=2.5e-06 rf_flag=0
M291 VDD PULL_ON 38 VDD P L=1.8e-07 W=2.5e-06 rf_flag=0
M292 VDD PULL_ON 68 VDD P L=1.8e-07 W=2.5e-06 rf_flag=0
M293 68 PULL_ON VDD VDD P L=1.8e-07 W=2.5e-06 rf_flag=0
M294 VDD PULL_ON 68 VDD P L=1.8e-07 W=2.5e-06 rf_flag=0
M295 68 PULL_ON VDD VDD P L=1.8e-07 W=2.5e-06 rf_flag=0
M296 VDD PULL_ON 68 VDD P L=1.8e-07 W=2.5e-06 rf_flag=0
M297 VDDO 52 50 VDDO P L=1.8e-07 W=7.5e-06 rf_flag=0
M298 64 50 VDDO VDDO P L=1.8e-07 W=7.5e-06 rf_flag=0
M299 VDDO 50 64 VDDO P L=1.8e-07 W=7.5e-06 rf_flag=0
M300 68 PULL_ON VDD VDD P L=1.8e-07 W=2.5e-06 rf_flag=0
M301 44 48 VDDO VDDO P L=1.8e-07 W=5e-06 rf_flag=0
M302 VDD PULL_ON 68 VDD P L=1.8e-07 W=2.5e-06 rf_flag=0
M303 86 37 44 VDDO P L=1.8e-07 W=2.7e-06 rf_flag=0
M304 68 PULL_ON VDD VDD P L=1.8e-07 W=2.5e-06 rf_flag=0
M305 88 55 44 VDDO P L=1.8e-07 W=1e-05 rf_flag=0
M306 88 54 VDDO VDDO P L=1.8e-07 W=1e-05 rf_flag=0
M307 VDDO 54 88 VDDO P L=1.8e-07 W=1e-05 rf_flag=0
M308 39 44 VDDO VDDO P L=1.8e-07 W=1e-05 rf_flag=0
M309 VDD PULL_UP_DOWN 68 VDD P L=1.8e-07 W=2.5e-06 rf_flag=0
M310 68 PULL_UP_DOWN VDD VDD P L=1.8e-07 W=2.5e-06 rf_flag=0
M311 VDD PULL_UP_DOWN 68 VDD P L=1.8e-07 W=2.5e-06 rf_flag=0
M312 49 51 VDDO VDDO P L=1.8e-07 W=7.5e-06 rf_flag=0
M313 VDDO 32 49 VDDO P L=1.8e-07 W=7.5e-06 rf_flag=0
M314 68 PULL_UP_DOWN VDD VDD P L=1.8e-07 W=2.5e-06 rf_flag=0
M315 VDD PULL_UP_DOWN 68 VDD P L=1.8e-07 W=2.5e-06 rf_flag=0
M316 68 PULL_UP_DOWN VDD VDD P L=1.8e-07 W=2.5e-06 rf_flag=0
M317 43 49 VDDO VDDO P L=1.8e-07 W=5e-06 rf_flag=0
M318 VDDO 49 43 VDDO P L=1.8e-07 W=5e-06 rf_flag=0
M319 43 49 VDDO VDDO P L=1.8e-07 W=5e-06 rf_flag=0
M320 VDD PULL_UP_DOWN 68 VDD P L=1.8e-07 W=2.5e-06 rf_flag=0
M321 VMAX 43 74 VMAX P L=1.8e-07 W=1e-05 rf_flag=0
M322 74 43 VMAX VMAX P L=1.8e-07 W=1e-05 rf_flag=0
M323 75 32 VMAX VMAX P L=1.8e-07 W=1e-05 rf_flag=0
M324 68 PULL_UP_DOWN VDD VDD P L=1.8e-07 W=2.5e-06 rf_flag=0
M325 PAD 74 VDDO VMAX P L=2.5e-07 W=2.08e-05 rf_flag=0
M326 VDDO 74 PAD VMAX P L=2.5e-07 W=2.08e-05 rf_flag=0
M327 PAD 74 VDDO VMAX P L=2.5e-07 W=2.08e-05 rf_flag=0
M328 VDDO 74 PAD VMAX P L=2.5e-07 W=2.08e-05 rf_flag=0
M329 PAD 74 VDDO VMAX P L=2.5e-07 W=2.08e-05 rf_flag=0
M330 VDDO 74 PAD VMAX P L=2.5e-07 W=2.08e-05 rf_flag=0
M331 PAD 74 VDDO VMAX P L=2.5e-07 W=2.08e-05 rf_flag=0
M332 VDDO 74 PAD VMAX P L=2.5e-07 W=2.08e-05 rf_flag=0
M333 PAD 74 VDDO VMAX P L=2.5e-07 W=2.08e-05 rf_flag=0
M334 VDDO 74 PAD VMAX P L=2.5e-07 W=2.08e-05 rf_flag=0
M335 PAD 75 VDDO VMAX P L=2.5e-07 W=2.08e-05 rf_flag=0
M336 VDDO 75 PAD VMAX P L=2.5e-07 W=2.08e-05 rf_flag=0
M337 PAD 75 VDDO VMAX P L=2.5e-07 W=2.08e-05 rf_flag=0
M338 VDDO 75 PAD VMAX P L=2.5e-07 W=2.08e-05 rf_flag=0
M339 PAD 75 VDDO VMAX P L=2.5e-07 W=2.08e-05 rf_flag=0
M340 VDDO 75 PAD VMAX P L=2.5e-07 W=2.08e-05 rf_flag=0
M341 PAD 52 VDDO VMAX P L=2.5e-07 W=2.08e-05 rf_flag=0
M342 VDDO 52 PAD VMAX P L=2.5e-07 W=2.08e-05 rf_flag=0
M343 PAD 52 VDDO VMAX P L=2.5e-07 W=2.08e-05 rf_flag=0
M344 VDDO 52 PAD VMAX P L=2.5e-07 W=2.08e-05 rf_flag=0
M345 VDD DRIVE_STR 59 VDD P L=1.8e-07 W=2.5e-06 rf_flag=0
M346 59 DRIVE_STR VDD VDD P L=1.8e-07 W=2.5e-06 rf_flag=0
M347 VMAX 32 52 VMAX P L=1.8e-07 W=6e-06 rf_flag=0
M348 VDDO 54 48 VDDO P L=1.8e-07 W=1e-05 rf_flag=0
M349 VDD DRIVE_STR 59 VDD P L=1.8e-07 W=2.5e-06 rf_flag=0
M350 VMAX 63 47 VMAX P L=1.8e-07 W=7.5e-06 rf_flag=0
M351 47 63 VMAX VMAX P L=1.8e-07 W=7.5e-06 rf_flag=0
M352 VMAX 35 47 VMAX P L=1.8e-07 W=7.5e-06 rf_flag=0
M353 47 35 VMAX VMAX P L=1.8e-07 W=7.5e-06 rf_flag=0
M354 VMAX 64 47 VMAX P L=1.8e-07 W=7.5e-06 rf_flag=0
M355 47 64 VMAX VMAX P L=1.8e-07 W=7.5e-06 rf_flag=0
M356 61 62 VMAX VMAX P L=1.8e-07 W=7e-06 rf_flag=0
M357 59 DRIVE_STR VDD VDD P L=1.8e-07 W=2.5e-06 rf_flag=0
M358 71 58 VDDO VDDO P L=1.8e-07 W=5e-06 rf_flag=0
M359 VDDO 58 71 VDDO P L=1.8e-07 W=5e-06 rf_flag=0
M360 71 58 VDDO VDDO P L=1.8e-07 W=5e-06 rf_flag=0
M361 VDDO 58 71 VDDO P L=1.8e-07 W=5e-06 rf_flag=0
M362 VDD 56 CIN VDD P L=1.8e-07 W=2.5e-06 rf_flag=0
M363 58 60 VDDO VDDO P L=1.8e-07 W=2.5e-06 rf_flag=0
M364 VDDO 60 58 VDDO P L=1.8e-07 W=2.5e-06 rf_flag=0
M365 58 VDDO_OK VDDO VDDO P L=1.8e-07 W=2.5e-06 rf_flag=0
M366 VDDO VDDO_OK 58 VDDO P L=1.8e-07 W=2.5e-06 rf_flag=0
M367 60 58 VDDO VDDO P L=1.8e-07 W=2e-06 rf_flag=0
M368 CIN 56 VDD VDD P L=1.8e-07 W=2.5e-06 rf_flag=0
M369 VDD 56 CIN VDD P L=1.8e-07 W=2.5e-06 rf_flag=0
M370 CIN 56 VDD VDD P L=1.8e-07 W=2.5e-06 rf_flag=0
M371 VDDO 61 55 VMAX P L=4e-06 W=2.5e-06 rf_flag=0
M372 VDD 56 CIN VDD P L=1.8e-07 W=2.5e-06 rf_flag=0
M373 66 67 VDDO VDDO P L=1.8e-07 W=2.5e-06 rf_flag=0
M374 VDDO 67 66 VDDO P L=1.8e-07 W=2.5e-06 rf_flag=0
M375 67 66 VDDO VDDO P L=1.8e-07 W=2e-06 rf_flag=0
M376 62 66 VDDO VDDO P L=1.8e-07 W=5e-06 rf_flag=0
M377 VDDO 66 62 VDDO P L=1.8e-07 W=5e-06 rf_flag=0
M378 62 66 VDDO VDDO P L=1.8e-07 W=5e-06 rf_flag=0
M379 VDDO 66 62 VDDO P L=1.8e-07 W=5e-06 rf_flag=0
M380 CIN 56 VDD VDD P L=1.8e-07 W=2.5e-06 rf_flag=0
M381 VDD 56 CIN VDD P L=1.8e-07 W=2.5e-06 rf_flag=0
M382 VDDO VMAX VMAX VMAX P L=1.8e-07 W=1.5e-05 rf_flag=0
M383 VMAX VMAX VDDO VMAX P L=1.8e-07 W=1.5e-05 rf_flag=0
M384 VDDO VMAX VMAX VMAX P L=1.8e-07 W=1.5e-05 rf_flag=0
M385 VMAX VMAX VDDO VMAX P L=1.8e-07 W=1.5e-05 rf_flag=0
M386 VMAX 55 VDDO VMAX P L=1.8e-07 W=1.5e-05 rf_flag=0
M387 55 76 VMAX VMAX P L=1.8e-07 W=1.5e-05 rf_flag=0
M388 CIN 56 VDD VDD P L=1.8e-07 W=2.5e-06 rf_flag=0
M389 VDDO 77 VMAX VMAX P L=1.8e-07 W=1.5e-05 rf_flag=0
M390 VMAX 77 VDDO VMAX P L=1.8e-07 W=1.5e-05 rf_flag=0
M391 VDDO 77 VMAX VMAX P L=1.8e-07 W=1.5e-05 rf_flag=0
M392 VMAX 77 VDDO VMAX P L=1.8e-07 W=1.5e-05 rf_flag=0
M393 VDDO 77 VMAX VMAX P L=1.8e-07 W=1.5e-05 rf_flag=0
M394 VMAX 77 VDDO VMAX P L=1.8e-07 W=1.5e-05 rf_flag=0
M395 VDDO 77 VMAX VMAX P L=1.8e-07 W=1.5e-05 rf_flag=0
M396 VMAX 77 VDDO VMAX P L=1.8e-07 W=1.5e-05 rf_flag=0
M397 VDDO 77 VMAX VMAX P L=1.8e-07 W=1.5e-05 rf_flag=0
M398 VMAX 77 VDDO VMAX P L=1.8e-07 W=1.5e-05 rf_flag=0
M399 VDDO 77 VMAX VMAX P L=1.8e-07 W=1.5e-05 rf_flag=0
M400 VMAX 77 VDDO VMAX P L=1.8e-07 W=1.5e-05 rf_flag=0
M401 VDDO 44 73 VDDO P L=1.8e-07 W=5e-06 rf_flag=0
M402 73 44 VDDO VDDO P L=1.8e-07 W=5e-06 rf_flag=0
M403 VDD VDD_OK 56 VDD P L=1.8e-07 W=2.5e-06 rf_flag=0
M404 56 VDD_OK VDD VDD P L=1.8e-07 W=2.5e-06 rf_flag=0
M405 VMAX 70 46 VMAX P L=1.8e-07 W=1e-05 rf_flag=0
M406 46 70 VMAX VMAX P L=1.8e-07 W=1e-05 rf_flag=0
M407 VDDO 34 63 VDDO P L=1.8e-07 W=7.5e-06 rf_flag=0
M408 63 34 VDDO VDDO P L=1.8e-07 W=7.5e-06 rf_flag=0
M409 VMAX 63 77 VMAX P L=1.8e-07 W=1e-05 rf_flag=0
M410 VDDO 71 97 VDDO P L=1.8e-07 W=7.5e-06 rf_flag=0
M411 97 71 VDDO VDDO P L=1.8e-07 W=7.5e-06 rf_flag=0
M412 70 47 97 VDDO P L=1.8e-07 W=7.5e-06 rf_flag=0
M413 97 47 70 VDDO P L=1.8e-07 W=7.5e-06 rf_flag=0
M414 VDDO 71 51 VDDO P L=1.8e-07 W=6e-06 rf_flag=0
M415 51 71 VDDO VDDO P L=1.8e-07 W=6e-06 rf_flag=0
M416 VDD 72 56 VDD P L=1e-06 W=2.5e-06 rf_flag=0
M417 72 56 VDD VDD P L=1.8e-07 W=2.5e-06 rf_flag=0
M418 VDD 56 72 VDD P L=1.8e-07 W=2.5e-06 rf_flag=0
M419 VDD 68 69 VDD P L=1.8e-07 W=2.5e-06 rf_flag=0
M420 69 68 VDD VDD P L=1.8e-07 W=2.5e-06 rf_flag=0
M421 VDD 68 69 VDD P L=1.8e-07 W=2.5e-06 rf_flag=0
M422 69 68 VDD VDD P L=1.8e-07 W=2.5e-06 rf_flag=0
R423 31 VSSO 1180.47 L=2.65e-06 W=1e-06 postlayout=1 $SUB=VSSO $[RD3]
R424 PAD 57 307.767 L=2.9e-06 W=4e-06 postlayout=1 $SUB=VMAX $[RD3]
R425 57 55 307.767 L=2.9e-06 W=4e-06 postlayout=1 $SUB=VMAX $[RD3]
R426 VDDO 76 4491.62 L=1.3e-05 W=1e-06 postlayout=1 $SUB=VMAX $[RD3]
D427 VSS VDDO dwn2psub AREA=2.70045e-09 PJ=0.00056982
D428 VSS VDD dwn2psub AREA=1.02344e-09 PJ=0.00044015
D429 VSSO VDDO dwn2psub AREA=2.70045e-09 PJ=0.00056982
D430 VSS VDD dwn2psub AREA=1.02344e-09 PJ=0.00044015
D431 VSS VDDO dwn2psub AREA=6.3586e-10 PJ=0.00063586
D432 VSSO VDDO dwn2psub AREA=6.3586e-10 PJ=0.00063586
D433 VSS VMAX dwn2psub AREA=4.73188e-09 PJ=0.00032045
D434 VSSO PAD dnpwcpl18 AREA=4.2e-11 PJ=4.42e-05 nf=1
D435 VSSO PAD dnpwcpl18 AREA=4.2e-11 PJ=4.42e-05 nf=1
.ENDS

.SUBCKT PIOH_50_18 PAD VSSO VSS VDD VDDO SCHM_ON EN IE VDDO_OK I PULL_UP_DOWN PULL_ON TTL_ON DRIVE_STR VDD_OK CIN
*.PININFO PAD:B VSSO:B VSS:B VDD:B VDDO:B SCHM_ON:I EN:I IE:I VDDO_OK:I I:I PULL_UP_DOWN:I PULL_ON:I TTL_ON:I DRIVE_STR:I VDD_OK:I CIN:O
M0 78 VDDO_OK 7 VSSO N5 L=6e-07 W=5e-06 rf_flag=0
M1 7 VDDO_OK 78 VSSO N5 L=6e-07 W=5e-06 rf_flag=0
M2 78 VDDO_OK 7 VSSO N5 L=6e-07 W=5e-06 rf_flag=0
M3 7 VDDO_OK 78 VSSO N5 L=6e-07 W=5e-06 rf_flag=0
M4 78 8 VSSO VSSO N5 L=6e-07 W=5e-06 rf_flag=0
M5 VSSO 8 78 VSSO N5 L=6e-07 W=5e-06 rf_flag=0
M6 78 8 VSSO VSSO N5 L=6e-07 W=5e-06 rf_flag=0
M7 VSSO 8 78 VSSO N5 L=6e-07 W=5e-06 rf_flag=0
M8 39 7 VSSO VSSO N5 L=6e-07 W=5e-06 rf_flag=0
M9 VSSO 7 39 VSSO N5 L=6e-07 W=5e-06 rf_flag=0
M10 39 7 VSSO VSSO N5 L=6e-07 W=5e-06 rf_flag=0
M11 27 IE VSSO VSSO N5 L=6e-07 W=6.5e-06 rf_flag=0
M12 VSSO IE 27 VSSO N5 L=6e-07 W=6.5e-06 rf_flag=0
M13 13 VDDO_OK VSSO VSSO N5 L=6e-07 W=3.75e-06 rf_flag=0
M14 VSSO VDDO_OK 13 VSSO N5 L=6e-07 W=3.75e-06 rf_flag=0
M15 11 SCHM_ON VSSO VSSO N5 L=6e-07 W=4.34e-06 rf_flag=0
M16 VSSO SCHM_ON 11 VSSO N5 L=6e-07 W=4.34e-06 rf_flag=0
M17 11 SCHM_ON VSSO VSSO N5 L=6e-07 W=4.34e-06 rf_flag=0
M18 17 VMAX VSSO VSSO N5 L=3e-06 W=5e-06 rf_flag=0
M19 VSSO 19 18 VSSO N5 L=6e-07 W=3e-06 rf_flag=0
M20 19 VDDO_OK VSSO VSSO N5 L=6e-07 W=3e-06 rf_flag=0
M21 80 26 VSSO VSSO N5 L=6e-07 W=5e-06 rf_flag=0
M22 VSSO 26 80 VSSO N5 L=6e-07 W=5e-06 rf_flag=0
M23 80 26 VSSO VSSO N5 L=6e-07 W=5e-06 rf_flag=0
M24 VSSO 26 80 VSSO N5 L=6e-07 W=5e-06 rf_flag=0
M25 21 EN VSSO VSSO N5 L=6e-07 W=4.5e-06 rf_flag=0
M26 VSSO EN 21 VSSO N5 L=6e-07 W=4.5e-06 rf_flag=0
M27 34 18 VSSO VSSO N5 L=6e-07 W=5e-06 rf_flag=0
M28 VSSO 18 34 VSSO N5 L=6e-07 W=5e-06 rf_flag=0
M29 34 18 VSSO VSSO N5 L=6e-07 W=5e-06 rf_flag=0
M30 80 VDDO_OK 18 VSSO N5 L=6e-07 W=5e-06 rf_flag=0
M31 18 VDDO_OK 80 VSSO N5 L=6e-07 W=5e-06 rf_flag=0
M32 80 VDDO_OK 18 VSSO N5 L=6e-07 W=5e-06 rf_flag=0
M33 18 VDDO_OK 80 VSSO N5 L=6e-07 W=5e-06 rf_flag=0
M34 32 20 VSSO VSSO N5 L=6e-07 W=5e-06 rf_flag=0
M35 VSSO 20 32 VSSO N5 L=6e-07 W=5e-06 rf_flag=0
M36 PAD 17 VSSO VSSO N5 L=6e-07 W=2.4e-05 rf_flag=0
M37 VSSO 14 PAD VSSO N5 L=6e-07 W=2.4e-05 rf_flag=0
M38 PAD 17 VSSO VSSO N5 L=6e-07 W=2.4e-05 rf_flag=0
M39 VSSO 14 PAD VSSO N5 L=6e-07 W=2.4e-05 rf_flag=0
M40 PAD 17 VSSO VSSO N5 L=6e-07 W=2.4e-05 rf_flag=0
M41 VSSO 14 PAD VSSO N5 L=6e-07 W=2.4e-05 rf_flag=0
M42 PAD 17 VSSO VSSO N5 L=6e-07 W=2.4e-05 rf_flag=0
M43 VSSO 15 PAD VSSO N5 L=6e-07 W=2.4e-05 rf_flag=0
M44 PAD 17 VSSO VSSO N5 L=6e-07 W=2.4e-05 rf_flag=0
M45 VSSO 15 PAD VSSO N5 L=6e-07 W=2.4e-05 rf_flag=0
M46 PAD 17 VSSO VSSO N5 L=6e-07 W=2.4e-05 rf_flag=0
M47 VSSO 15 PAD VSSO N5 L=6e-07 W=2.4e-05 rf_flag=0
M48 PAD 17 VSSO VSSO N5 L=6e-07 W=2.4e-05 rf_flag=0
M49 VSSO 16 PAD VSSO N5 L=6e-07 W=2.4e-05 rf_flag=0
M50 PAD 17 VSSO VSSO N5 L=6e-07 W=2.4e-05 rf_flag=0
M51 VSSO 16 PAD VSSO N5 L=6e-07 W=2.4e-05 rf_flag=0
M52 32 13 VSSO VSSO N5 L=6e-07 W=2e-06 rf_flag=0
M53 VSSO 22 52 VSSO N5 L=6e-07 W=1e-05 rf_flag=0
M54 52 22 VSSO VSSO N5 L=6e-07 W=1e-05 rf_flag=0
M55 VSSO 24 52 VSSO N5 L=8e-06 W=1.5e-06 rf_flag=0
M56 54 23 VSSO VSSO N5 L=6e-07 W=1e-05 rf_flag=0
M57 VSSO 23 54 VSSO N5 L=6e-07 W=1e-05 rf_flag=0
M58 54 23 VSSO VSSO N5 L=6e-07 W=1e-05 rf_flag=0
M59 81 VDDO_OK 28 VSSO N5 L=6e-07 W=5e-06 rf_flag=0
M60 28 VDDO_OK 81 VSSO N5 L=6e-07 W=5e-06 rf_flag=0
M61 81 VDDO_OK 28 VSSO N5 L=6e-07 W=5e-06 rf_flag=0
M62 28 VDDO_OK 81 VSSO N5 L=6e-07 W=5e-06 rf_flag=0
M63 81 29 VSSO VSSO N5 L=6e-07 W=5e-06 rf_flag=0
M64 VSSO 29 81 VSSO N5 L=6e-07 W=5e-06 rf_flag=0
M65 81 29 VSSO VSSO N5 L=6e-07 W=5e-06 rf_flag=0
M66 VSSO 29 81 VSSO N5 L=6e-07 W=5e-06 rf_flag=0
M67 35 28 VSSO VSSO N5 L=6e-07 W=5e-06 rf_flag=0
M68 VSSO 28 35 VSSO N5 L=6e-07 W=5e-06 rf_flag=0
M69 35 28 VSSO VSSO N5 L=6e-07 W=5e-06 rf_flag=0
M70 31 I VSSO VSSO N5 L=6e-07 W=4.5e-06 rf_flag=0
M71 VSSO I 31 VSSO N5 L=6e-07 W=4.5e-06 rf_flag=0
M72 51 32 VSSO VSSO N5 L=6e-07 W=3.75e-06 rf_flag=0
M73 VSSO 32 51 VSSO N5 L=6e-07 W=3.75e-06 rf_flag=0
M74 VSSO 33 14 VSSO N5 L=6e-07 W=1.5e-05 rf_flag=0
M75 14 33 VSSO VSSO N5 L=6e-07 W=1.5e-05 rf_flag=0
M76 VSSO 36 23 VSSO N5 L=6e-07 W=5e-06 rf_flag=0
M77 23 36 VSSO VSSO N5 L=6e-07 W=5e-06 rf_flag=0
M78 VSSO 36 23 VSSO N5 L=6e-07 W=5e-06 rf_flag=0
M79 23 35 VSSO VSSO N5 L=6e-07 W=5e-06 rf_flag=0
M80 VSSO 35 23 VSSO N5 L=6e-07 W=5e-06 rf_flag=0
M81 23 35 VSSO VSSO N5 L=6e-07 W=5e-06 rf_flag=0
M82 VSSO 34 23 VSSO N5 L=6e-07 W=5e-06 rf_flag=0
M83 23 34 VSSO VSSO N5 L=6e-07 W=5e-06 rf_flag=0
M84 VSSO 34 23 VSSO N5 L=6e-07 W=5e-06 rf_flag=0
M85 76 37 75 VSSO N5 L=6e-07 W=1e-05 rf_flag=0
M86 75 37 76 VSSO N5 L=6e-07 W=1e-05 rf_flag=0
M87 76 37 75 VSSO N5 L=6e-07 W=1e-05 rf_flag=0
M88 54 23 76 VSSO N5 L=6e-07 W=1e-05 rf_flag=0
M89 76 23 54 VSSO N5 L=6e-07 W=1e-05 rf_flag=0
M90 54 23 76 VSSO N5 L=6e-07 W=1e-05 rf_flag=0
M91 VSSO 40 36 VSSO N5 L=6e-07 W=5e-06 rf_flag=0
M92 36 40 VSSO VSSO N5 L=6e-07 W=5e-06 rf_flag=0
M93 VSSO 41 16 VSSO N5 L=6e-07 W=7.5e-06 rf_flag=0
M94 16 41 VSSO VSSO N5 L=6e-07 W=7.5e-06 rf_flag=0
M95 VSSO 41 15 VSSO N5 L=6e-07 W=7.5e-06 rf_flag=0
M96 15 41 VSSO VSSO N5 L=6e-07 W=7.5e-06 rf_flag=0
M97 VSSO 39 43 VSSO N5 L=6e-07 W=5e-06 rf_flag=0
M98 44 46 VSSO VSSO N5 L=6e-07 W=5e-06 rf_flag=0
M99 85 44 VSSO VSSO N5 L=6e-07 W=2e-06 rf_flag=0
M100 46 43 85 VSSO N5 L=6e-07 W=1.3e-06 rf_flag=0
M101 VSSO 16 40 VSSO N5 L=6e-07 W=5e-06 rf_flag=0
M102 56 48 VSSO VSSO N5 L=6e-07 W=1e-05 rf_flag=0
M103 46 TTL_ON 89 VSSO N5 L=6e-07 W=8.335e-06 rf_flag=0
M104 89 TTL_ON 46 VSSO N5 L=6e-07 W=8.335e-06 rf_flag=0
M105 46 TTL_ON 89 VSSO N5 L=6e-07 W=8.335e-06 rf_flag=0
M106 VSSO 50 37 VSSO N5 L=6e-07 W=1e-05 rf_flag=0
M107 37 50 VSSO VSSO N5 L=6e-07 W=1e-05 rf_flag=0
M108 91 49 VSSO VSSO N5 L=6e-07 W=1e-05 rf_flag=0
M109 VSSO 49 91 VSSO N5 L=6e-07 W=1e-05 rf_flag=0
M110 91 52 89 VSSO N5 L=6e-07 W=8.335e-06 rf_flag=0
M111 89 52 91 VSSO N5 L=6e-07 W=8.335e-06 rf_flag=0
M112 91 52 89 VSSO N5 L=6e-07 W=8.335e-06 rf_flag=0
M113 VSSO 23 90 VSSO N5 L=6e-07 W=5e-06 rf_flag=0
M114 90 23 VSSO VSSO N5 L=6e-07 W=5e-06 rf_flag=0
M115 50 53 90 VSSO N5 L=6e-07 W=5e-06 rf_flag=0
M116 90 53 50 VSSO N5 L=6e-07 W=5e-06 rf_flag=0
M117 48 54 VSSO VSSO N5 L=6e-07 W=5e-06 rf_flag=0
M118 46 52 91 VSSO N5 L=6e-07 W=5e-06 rf_flag=0
M119 92 58 VSSO VSSO N5 L=6e-07 W=1.5e-05 rf_flag=0
M120 93 35 92 VSSO N5 L=6e-07 W=1.5e-05 rf_flag=0
M121 41 56 93 VSSO N5 L=6e-07 W=1.5e-05 rf_flag=0
M122 95 VDDO_OK 60 VSSO N5 L=6e-07 W=5e-06 rf_flag=0
M123 60 VDDO_OK 95 VSSO N5 L=6e-07 W=5e-06 rf_flag=0
M124 95 VDDO_OK 60 VSSO N5 L=6e-07 W=5e-06 rf_flag=0
M125 60 VDDO_OK 95 VSSO N5 L=6e-07 W=5e-06 rf_flag=0
M126 95 61 VSSO VSSO N5 L=6e-07 W=5e-06 rf_flag=0
M127 VSSO 61 95 VSSO N5 L=6e-07 W=5e-06 rf_flag=0
M128 95 61 VSSO VSSO N5 L=6e-07 W=5e-06 rf_flag=0
M129 VSSO 61 95 VSSO N5 L=6e-07 W=5e-06 rf_flag=0
M130 72 60 VSSO VSSO N5 L=6e-07 W=5e-06 rf_flag=0
M131 VSSO 60 72 VSSO N5 L=6e-07 W=5e-06 rf_flag=0
M132 72 60 VSSO VSSO N5 L=6e-07 W=5e-06 rf_flag=0
M133 62 DRIVE_STR VSSO VSSO N5 L=6e-07 W=4.5e-06 rf_flag=0
M134 VSSO DRIVE_STR 62 VSSO N5 L=6e-07 W=4.5e-06 rf_flag=0
M135 49 51 VSSO VSSO N5 L=6e-07 W=3.75e-06 rf_flag=0
M136 VSSO 51 49 VSSO N5 L=6e-07 W=3.75e-06 rf_flag=0
M137 96 VDD_OK 57 VSS N5 L=6e-07 W=7e-06 rf_flag=0
M138 57 VDD_OK 96 VSS N5 L=6e-07 W=7e-06 rf_flag=0
M139 96 VDD_OK 57 VSS N5 L=6e-07 W=7e-06 rf_flag=0
M140 67 70 VSSO VSSO N5 L=6e-07 W=5e-06 rf_flag=0
M141 VSSO 70 67 VSSO N5 L=6e-07 W=5e-06 rf_flag=0
M142 67 70 VSSO VSSO N5 L=6e-07 W=5e-06 rf_flag=0
M143 VSSO 70 67 VSSO N5 L=6e-07 W=5e-06 rf_flag=0
M144 69 65 VSSO VSSO N5 L=6e-07 W=4.5e-06 rf_flag=0
M145 VSSO 65 69 VSSO N5 L=6e-07 W=4.5e-06 rf_flag=0
M146 64 67 VSSO VSSO N5 L=6e-07 W=5e-06 rf_flag=0
M147 VSSO 67 64 VSSO N5 L=6e-07 W=5e-06 rf_flag=0
M148 64 67 VSSO VSSO N5 L=6e-07 W=5e-06 rf_flag=0
M149 57 VDD_OK 96 VSS N5 L=6e-07 W=7e-06 rf_flag=0
M150 96 VDD_OK 57 VSS N5 L=6e-07 W=7e-06 rf_flag=0
M151 VSS 73 96 VSS N5 L=6e-07 W=7e-06 rf_flag=0
M152 96 73 VSS VSS N5 L=6e-07 W=7e-06 rf_flag=0
M153 VSS 73 96 VSS N5 L=6e-07 W=7e-06 rf_flag=0
M154 96 73 VSS VSS N5 L=6e-07 W=7e-06 rf_flag=0
M155 VSSO 64 63 VSSO N5 L=6e-07 W=5e-06 rf_flag=0
M156 73 46 VSSO VSSO N5 L=6e-07 W=5e-06 rf_flag=0
M157 VSSO 46 73 VSSO N5 L=6e-07 W=5e-06 rf_flag=0
M158 VSS 73 96 VSS N5 L=6e-07 W=7e-06 rf_flag=0
M159 VSSO 72 53 VSSO N5 L=6e-07 W=7.5e-06 rf_flag=0
M160 53 72 VSSO VSSO N5 L=6e-07 W=7.5e-06 rf_flag=0
M161 VSSO 71 33 VSSO N5 L=6e-07 W=7.5e-06 rf_flag=0
M162 33 71 VSSO VSSO N5 L=6e-07 W=7.5e-06 rf_flag=0
M163 VSSO 34 58 VSSO N5 L=6e-07 W=7.5e-06 rf_flag=0
M164 58 34 VSSO VSSO N5 L=6e-07 W=7.5e-06 rf_flag=0
M165 VSS 46 74 VSS N5 L=6e-07 W=4.5e-06 rf_flag=0
M166 71 72 VSSO VSSO N5 L=6e-07 W=5e-06 rf_flag=0
M167 VSSO 72 71 VSSO N5 L=6e-07 W=5e-06 rf_flag=0
M168 71 41 VSSO VSSO N5 L=6e-07 W=5e-06 rf_flag=0
M169 VSSO 41 71 VSSO N5 L=6e-07 W=5e-06 rf_flag=0
M170 68 58 VSSO VSSO N5 L=6e-07 W=5e-06 rf_flag=0
M171 VSSO 58 68 VSSO N5 L=6e-07 W=5e-06 rf_flag=0
M172 74 46 VSS VSS N5 L=6e-07 W=4.5e-06 rf_flag=0
M173 VSS SCHM_ON 8 VSS N L=1.8e-07 W=2.5e-06 rf_flag=0
M174 8 SCHM_ON VSS VSS N L=1.8e-07 W=2.5e-06 rf_flag=0
M175 20 IE VSS VSS N L=1.8e-07 W=2.5e-06 rf_flag=0
M176 VSS IE 20 VSS N L=1.8e-07 W=2.5e-06 rf_flag=0
M177 VSS EN 26 VSS N L=1.8e-07 W=2.5e-06 rf_flag=0
M178 26 EN VSS VSS N L=1.8e-07 W=2.5e-06 rf_flag=0
M179 VSS EN 26 VSS N L=1.8e-07 W=2.5e-06 rf_flag=0
M180 26 EN VSS VSS N L=1.8e-07 W=2.5e-06 rf_flag=0
M181 VSS I 29 VSS N L=1.8e-07 W=2.5e-06 rf_flag=0
M182 29 I VSS VSS N L=1.8e-07 W=2.5e-06 rf_flag=0
M183 VSS I 29 VSS N L=1.8e-07 W=2.5e-06 rf_flag=0
M184 29 I VSS VSS N L=1.8e-07 W=2.5e-06 rf_flag=0
M185 VSS PULL_UP_DOWN 24 VSS N L=1.8e-07 W=3.75e-06 rf_flag=0
M186 24 PULL_UP_DOWN VSS VSS N L=1.8e-07 W=3.75e-06 rf_flag=0
M187 VSS PULL_UP_DOWN 24 VSS N L=1.8e-07 W=3.75e-06 rf_flag=0
M188 24 PULL_UP_DOWN VSS VSS N L=1.8e-07 W=3.75e-06 rf_flag=0
M189 VSS 42 24 VSS N L=1.8e-07 W=3.75e-06 rf_flag=0
M190 24 42 VSS VSS N L=1.8e-07 W=3.75e-06 rf_flag=0
M191 VSS 42 24 VSS N L=1.8e-07 W=3.75e-06 rf_flag=0
M192 24 42 VSS VSS N L=1.8e-07 W=3.75e-06 rf_flag=0
M193 42 PULL_ON VSS VSS N L=1.8e-07 W=3.5e-06 rf_flag=0
M194 VSS PULL_ON 42 VSS N L=1.8e-07 W=3.5e-06 rf_flag=0
M195 VSS PULL_ON 87 VSS N L=1.8e-07 W=3.5e-06 rf_flag=0
M196 87 PULL_ON VSS VSS N L=1.8e-07 W=3.5e-06 rf_flag=0
M197 65 PULL_UP_DOWN 87 VSS N L=1.8e-07 W=3.5e-06 rf_flag=0
M198 87 PULL_UP_DOWN 65 VSS N L=1.8e-07 W=3.5e-06 rf_flag=0
M199 VSS DRIVE_STR 61 VSS N L=1.8e-07 W=5e-06 rf_flag=0
M200 61 DRIVE_STR VSS VSS N L=1.8e-07 W=5e-06 rf_flag=0
M201 CIN 57 VSS VSS N L=1.8e-07 W=5e-06 rf_flag=0
M202 VSS 57 CIN VSS N L=1.8e-07 W=5e-06 rf_flag=0
M203 CIN 57 VSS VSS N L=1.8e-07 W=5e-06 rf_flag=0
M204 VSS 65 70 VSS N L=1.8e-07 W=5e-06 rf_flag=0
M205 70 65 VSS VSS N L=1.8e-07 W=5e-06 rf_flag=0
M206 13 VDDO_OK VDDO VDDO P5 L=5e-07 W=5e-06 rf_flag=0
M207 VDDO VDDO_OK 13 VDDO P5 L=5e-07 W=5e-06 rf_flag=0
M208 39 7 VDDO VDDO P5 L=5e-07 W=5.01e-06 rf_flag=0
M209 VDDO 7 39 VDDO P5 L=5e-07 W=5.01e-06 rf_flag=0
M210 39 7 VDDO VDDO P5 L=5e-07 W=5.01e-06 rf_flag=0
M211 VDDO 7 39 VDDO P5 L=5e-07 W=5.01e-06 rf_flag=0
M212 7 11 VDDO VDDO P5 L=5e-07 W=2.5e-06 rf_flag=0
M213 VDDO 11 7 VDDO P5 L=5e-07 W=2.5e-06 rf_flag=0
M214 7 VDDO_OK VDDO VDDO P5 L=5e-07 W=2.5e-06 rf_flag=0
M215 VDDO VDDO_OK 7 VDDO P5 L=5e-07 W=2.5e-06 rf_flag=0
M216 11 7 VDDO VDDO P5 L=5e-07 W=2e-06 rf_flag=0
M217 18 21 VDDO VDDO P5 L=5e-07 W=2.5e-06 rf_flag=0
M218 VDDO 21 18 VDDO P5 L=5e-07 W=2.5e-06 rf_flag=0
M219 19 VDDO_OK VDDO VDDO P5 L=5e-07 W=2.5e-06 rf_flag=0
M220 VDDO VDDO_OK 19 VDDO P5 L=5e-07 W=2.5e-06 rf_flag=0
M221 21 18 VDDO VDDO P5 L=5e-07 W=2e-06 rf_flag=0
M222 34 18 VDDO VDDO P5 L=5e-07 W=5e-06 rf_flag=0
M223 VDDO 18 34 VDDO P5 L=5e-07 W=5e-06 rf_flag=0
M224 34 18 VDDO VDDO P5 L=5e-07 W=5e-06 rf_flag=0
M225 VDDO 18 34 VDDO P5 L=5e-07 W=5e-06 rf_flag=0
M226 79 27 32 VDDO P5 L=5e-07 W=5e-06 rf_flag=0
M227 VDDO 13 79 VDDO P5 L=5e-07 W=5e-06 rf_flag=0
M228 79 13 VDDO VDDO P5 L=5e-07 W=5e-06 rf_flag=0
M229 VDDO 13 79 VDDO P5 L=5e-07 W=5e-06 rf_flag=0
M230 VDDO 32 27 VDDO P5 L=5e-07 W=2e-06 rf_flag=0
M231 35 28 VDDO VDDO P5 L=5e-07 W=5e-06 rf_flag=0
M232 VDDO 28 35 VDDO P5 L=5e-07 W=5e-06 rf_flag=0
M233 35 28 VDDO VDDO P5 L=5e-07 W=5e-06 rf_flag=0
M234 VDDO 28 35 VDDO P5 L=5e-07 W=5e-06 rf_flag=0
M235 28 31 VDDO VDDO P5 L=5e-07 W=2.5e-06 rf_flag=0
M236 VDDO 31 28 VDDO P5 L=5e-07 W=2.5e-06 rf_flag=0
M237 28 VDDO_OK VDDO VDDO P5 L=5e-07 W=2.5e-06 rf_flag=0
M238 VDDO VDDO_OK 28 VDDO P5 L=5e-07 W=2.5e-06 rf_flag=0
M239 51 32 VDDO VDDO P5 L=5e-07 W=5e-06 rf_flag=0
M240 VDDO 32 51 VDDO P5 L=5e-07 W=5e-06 rf_flag=0
M241 31 28 VDDO VDDO P5 L=5e-07 W=2e-06 rf_flag=0
M242 43 39 VDDO VDDO P5 L=5e-07 W=6e-06 rf_flag=0
M243 82 34 23 VDDO P5 L=5e-07 W=5e-06 rf_flag=0
M244 23 34 82 VDDO P5 L=5e-07 W=5e-06 rf_flag=0
M245 82 34 23 VDDO P5 L=5e-07 W=5e-06 rf_flag=0
M246 83 35 82 VDDO P5 L=5e-07 W=5e-06 rf_flag=0
M247 82 35 83 VDDO P5 L=5e-07 W=5e-06 rf_flag=0
M248 83 35 82 VDDO P5 L=5e-07 W=5e-06 rf_flag=0
M249 VDDO 36 83 VDDO P5 L=5e-07 W=5e-06 rf_flag=0
M250 83 36 VDDO VDDO P5 L=5e-07 W=5e-06 rf_flag=0
M251 VDDO 36 83 VDDO P5 L=5e-07 W=5e-06 rf_flag=0
M252 15 33 14 VDDO P5 L=5e-07 W=1e-05 rf_flag=0
M253 14 33 15 VDDO P5 L=5e-07 W=1e-05 rf_flag=0
M254 15 33 14 VDDO P5 L=5e-07 W=1e-05 rf_flag=0
M255 16 41 15 VDDO P5 L=5e-07 W=1e-05 rf_flag=0
M256 15 41 16 VDDO P5 L=5e-07 W=1e-05 rf_flag=0
M257 16 41 15 VDDO P5 L=5e-07 W=1e-05 rf_flag=0
M258 VDDO 41 16 VDDO P5 L=5e-07 W=1e-05 rf_flag=0
M259 16 41 VDDO VDDO P5 L=5e-07 W=1e-05 rf_flag=0
M260 VDDO 41 16 VDDO P5 L=5e-07 W=1e-05 rf_flag=0
M261 VDDO 40 36 VDDO P5 L=5e-07 W=7.5e-06 rf_flag=0
M262 36 40 VDDO VDDO P5 L=5e-07 W=7.5e-06 rf_flag=0
M263 40 16 VDDO VDDO P5 L=5e-07 W=7.5e-06 rf_flag=0
M264 VDDO 44 86 VDDO P5 L=5e-07 W=5e-06 rf_flag=0
M265 VDDO 54 48 VDDO P5 L=5e-07 W=7.5e-06 rf_flag=0
M266 56 48 VDDO VDDO P5 L=5e-07 W=7.5e-06 rf_flag=0
M267 VDDO 48 56 VDDO P5 L=5e-07 W=7.5e-06 rf_flag=0
M268 46 49 VDDO VDDO P5 L=5e-07 W=5e-06 rf_flag=0
M269 86 39 46 VDDO P5 L=5e-07 W=2.7e-06 rf_flag=0
M270 88 52 46 VDDO P5 L=5e-07 W=1e-05 rf_flag=0
M271 88 51 VDDO VDDO P5 L=5e-07 W=1e-05 rf_flag=0
M272 VDDO 51 88 VDDO P5 L=5e-07 W=1e-05 rf_flag=0
M273 44 46 VDDO VDDO P5 L=5e-07 W=1e-05 rf_flag=0
M274 50 53 VDDO VDDO P5 L=5e-07 W=7.5e-06 rf_flag=0
M275 VDDO 23 50 VDDO P5 L=5e-07 W=7.5e-06 rf_flag=0
M276 37 50 VDDO VDDO P5 L=5e-07 W=5e-06 rf_flag=0
M277 VDDO 50 37 VDDO P5 L=5e-07 W=5e-06 rf_flag=0
M278 37 50 VDDO VDDO P5 L=5e-07 W=5e-06 rf_flag=0
M279 VMAX 37 75 VMAX P5 L=5e-07 W=1e-05 rf_flag=0
M280 75 37 VMAX VMAX P5 L=5e-07 W=1e-05 rf_flag=0
M281 76 23 VMAX VMAX P5 L=5e-07 W=1e-05 rf_flag=0
M282 PAD 75 VDDO VMAX P5 L=5e-07 W=2.08e-05 rf_flag=0
M283 VDDO 75 PAD VMAX P5 L=5e-07 W=2.08e-05 rf_flag=0
M284 PAD 75 VDDO VMAX P5 L=5e-07 W=2.08e-05 rf_flag=0
M285 VDDO 75 PAD VMAX P5 L=5e-07 W=2.08e-05 rf_flag=0
M286 PAD 75 VDDO VMAX P5 L=5e-07 W=2.08e-05 rf_flag=0
M287 VDDO 75 PAD VMAX P5 L=5e-07 W=2.08e-05 rf_flag=0
M288 PAD 75 VDDO VMAX P5 L=5e-07 W=2.08e-05 rf_flag=0
M289 VDDO 75 PAD VMAX P5 L=5e-07 W=2.08e-05 rf_flag=0
M290 PAD 75 VDDO VMAX P5 L=5e-07 W=2.08e-05 rf_flag=0
M291 VDDO 75 PAD VMAX P5 L=5e-07 W=2.08e-05 rf_flag=0
M292 PAD 76 VDDO VMAX P5 L=5e-07 W=2.08e-05 rf_flag=0
M293 VDDO 76 PAD VMAX P5 L=5e-07 W=2.08e-05 rf_flag=0
M294 PAD 76 VDDO VMAX P5 L=5e-07 W=2.08e-05 rf_flag=0
M295 VDDO 76 PAD VMAX P5 L=5e-07 W=2.08e-05 rf_flag=0
M296 PAD 76 VDDO VMAX P5 L=5e-07 W=2.08e-05 rf_flag=0
M297 VDDO 76 PAD VMAX P5 L=5e-07 W=2.08e-05 rf_flag=0
M298 PAD 54 VDDO VMAX P5 L=5e-07 W=2.08e-05 rf_flag=0
M299 VDDO 54 PAD VMAX P5 L=5e-07 W=2.08e-05 rf_flag=0
M300 PAD 54 VDDO VMAX P5 L=5e-07 W=2.08e-05 rf_flag=0
M301 VDDO 54 PAD VMAX P5 L=5e-07 W=2.08e-05 rf_flag=0
M302 VMAX 23 54 VMAX P5 L=5e-07 W=6e-06 rf_flag=0
M303 VDDO 51 49 VDDO P5 L=5e-07 W=1e-05 rf_flag=0
M304 VMAX 58 41 VMAX P5 L=5e-07 W=7.5e-06 rf_flag=0
M305 41 58 VMAX VMAX P5 L=5e-07 W=7.5e-06 rf_flag=0
M306 VMAX 35 41 VMAX P5 L=5e-07 W=7.5e-06 rf_flag=0
M307 41 35 VMAX VMAX P5 L=5e-07 W=7.5e-06 rf_flag=0
M308 VMAX 56 41 VMAX P5 L=5e-07 W=7.5e-06 rf_flag=0
M309 41 56 VMAX VMAX P5 L=5e-07 W=7.5e-06 rf_flag=0
M310 63 64 VMAX VMAX P5 L=5e-07 W=7e-06 rf_flag=0
M311 72 60 VDDO VDDO P5 L=5e-07 W=5e-06 rf_flag=0
M312 VDDO 60 72 VDDO P5 L=5e-07 W=5e-06 rf_flag=0
M313 72 60 VDDO VDDO P5 L=5e-07 W=5e-06 rf_flag=0
M314 VDDO 60 72 VDDO P5 L=5e-07 W=5e-06 rf_flag=0
M315 60 62 VDDO VDDO P5 L=5e-07 W=2.5e-06 rf_flag=0
M316 VDDO 62 60 VDDO P5 L=5e-07 W=2.5e-06 rf_flag=0
M317 60 VDDO_OK VDDO VDDO P5 L=5e-07 W=2.5e-06 rf_flag=0
M318 VDDO VDDO_OK 60 VDDO P5 L=5e-07 W=2.5e-06 rf_flag=0
M319 62 60 VDDO VDDO P5 L=5e-07 W=2e-06 rf_flag=0
M320 VDDO 63 52 VMAX P5 L=4e-06 W=2.5e-06 rf_flag=0
M321 67 69 VDDO VDDO P5 L=5e-07 W=2.5e-06 rf_flag=0
M322 VDDO 69 67 VDDO P5 L=5e-07 W=2.5e-06 rf_flag=0
M323 69 67 VDDO VDDO P5 L=5e-07 W=2e-06 rf_flag=0
M324 64 67 VDDO VDDO P5 L=5e-07 W=5e-06 rf_flag=0
M325 VDDO 67 64 VDDO P5 L=5e-07 W=5e-06 rf_flag=0
M326 64 67 VDDO VDDO P5 L=5e-07 W=5e-06 rf_flag=0
M327 VDDO 67 64 VDDO P5 L=5e-07 W=5e-06 rf_flag=0
M328 VDDO VMAX VMAX VMAX P5 L=5e-07 W=1.5e-05 rf_flag=0
M329 VMAX VMAX VDDO VMAX P5 L=5e-07 W=1.5e-05 rf_flag=0
M330 VDDO VMAX VMAX VMAX P5 L=5e-07 W=1.5e-05 rf_flag=0
M331 VMAX VMAX VDDO VMAX P5 L=5e-07 W=1.5e-05 rf_flag=0
M332 VMAX 52 VDDO VMAX P5 L=5e-07 W=1.5e-05 rf_flag=0
M333 52 77 VMAX VMAX P5 L=5e-07 W=1.5e-05 rf_flag=0
M334 VDDO 68 VMAX VMAX P5 L=5e-07 W=1.5e-05 rf_flag=0
M335 VMAX 68 VDDO VMAX P5 L=5e-07 W=1.5e-05 rf_flag=0
M336 VDDO 68 VMAX VMAX P5 L=5e-07 W=1.5e-05 rf_flag=0
M337 VMAX 68 VDDO VMAX P5 L=5e-07 W=1.5e-05 rf_flag=0
M338 VDDO 68 VMAX VMAX P5 L=5e-07 W=1.5e-05 rf_flag=0
M339 VMAX 68 VDDO VMAX P5 L=5e-07 W=1.5e-05 rf_flag=0
M340 VDDO 68 VMAX VMAX P5 L=5e-07 W=1.5e-05 rf_flag=0
M341 VMAX 68 VDDO VMAX P5 L=5e-07 W=1.5e-05 rf_flag=0
M342 VDDO 68 VMAX VMAX P5 L=5e-07 W=1.5e-05 rf_flag=0
M343 VMAX 68 VDDO VMAX P5 L=5e-07 W=1.5e-05 rf_flag=0
M344 VDDO 68 VMAX VMAX P5 L=5e-07 W=1.5e-05 rf_flag=0
M345 VMAX 68 VDDO VMAX P5 L=5e-07 W=1.5e-05 rf_flag=0
M346 VDDO 46 73 VDDO P5 L=5e-07 W=5e-06 rf_flag=0
M347 73 46 VDDO VDDO P5 L=5e-07 W=5e-06 rf_flag=0
M348 VMAX 71 33 VMAX P5 L=5e-07 W=1e-05 rf_flag=0
M349 33 71 VMAX VMAX P5 L=5e-07 W=1e-05 rf_flag=0
M350 VDDO 34 58 VDDO P5 L=5e-07 W=7.5e-06 rf_flag=0
M351 58 34 VDDO VDDO P5 L=5e-07 W=7.5e-06 rf_flag=0
M352 VMAX 58 68 VMAX P5 L=5e-07 W=1e-05 rf_flag=0
M353 VDDO 72 97 VDDO P5 L=5e-07 W=7.5e-06 rf_flag=0
M354 97 72 VDDO VDDO P5 L=5e-07 W=7.5e-06 rf_flag=0
M355 71 41 97 VDDO P5 L=5e-07 W=7.5e-06 rf_flag=0
M356 97 41 71 VDDO P5 L=5e-07 W=7.5e-06 rf_flag=0
M357 VDDO 72 53 VDDO P5 L=5e-07 W=6e-06 rf_flag=0
M358 53 72 VDDO VDDO P5 L=5e-07 W=6e-06 rf_flag=0
M359 VDD SCHM_ON 8 VDD P L=1.8e-07 W=2.5e-06 rf_flag=0
M360 8 SCHM_ON VDD VDD P L=1.8e-07 W=2.5e-06 rf_flag=0
M361 VDD SCHM_ON 8 VDD P L=1.8e-07 W=2.5e-06 rf_flag=0
M362 8 SCHM_ON VDD VDD P L=1.8e-07 W=2.5e-06 rf_flag=0
M363 20 IE VDD VDD P L=1.8e-07 W=3.335e-06 rf_flag=0
M364 VDD IE 20 VDD P L=1.8e-07 W=3.335e-06 rf_flag=0
M365 20 IE VDD VDD P L=1.8e-07 W=3.335e-06 rf_flag=0
M366 VDD EN 26 VDD P L=1.8e-07 W=2.5e-06 rf_flag=0
M367 26 EN VDD VDD P L=1.8e-07 W=2.5e-06 rf_flag=0
M368 VDD EN 26 VDD P L=1.8e-07 W=2.5e-06 rf_flag=0
M369 26 EN VDD VDD P L=1.8e-07 W=2.5e-06 rf_flag=0
M370 VDD I 29 VDD P L=1.8e-07 W=2.5e-06 rf_flag=0
M371 29 I VDD VDD P L=1.8e-07 W=2.5e-06 rf_flag=0
M372 VDD I 29 VDD P L=1.8e-07 W=2.5e-06 rf_flag=0
M373 29 I VDD VDD P L=1.8e-07 W=2.5e-06 rf_flag=0
M374 24 PULL_UP_DOWN 84 VDD P L=1.8e-07 W=2e-06 rf_flag=0
M375 84 PULL_UP_DOWN 24 VDD P L=1.8e-07 W=2e-06 rf_flag=0
M376 24 PULL_UP_DOWN 84 VDD P L=1.8e-07 W=2e-06 rf_flag=0
M377 84 PULL_UP_DOWN 24 VDD P L=1.8e-07 W=2e-06 rf_flag=0
M378 VDD 42 84 VDD P L=1.8e-07 W=2e-06 rf_flag=0
M379 84 42 VDD VDD P L=1.8e-07 W=2e-06 rf_flag=0
M380 VDD 42 84 VDD P L=1.8e-07 W=2e-06 rf_flag=0
M381 84 42 VDD VDD P L=1.8e-07 W=2e-06 rf_flag=0
M382 42 PULL_ON VDD VDD P L=1.8e-07 W=2.5e-06 rf_flag=0
M383 VDD PULL_ON 42 VDD P L=1.8e-07 W=2.5e-06 rf_flag=0
M384 42 PULL_ON VDD VDD P L=1.8e-07 W=2.5e-06 rf_flag=0
M385 VDD PULL_ON 42 VDD P L=1.8e-07 W=2.5e-06 rf_flag=0
M386 VDD PULL_ON 65 VDD P L=1.8e-07 W=2.5e-06 rf_flag=0
M387 65 PULL_ON VDD VDD P L=1.8e-07 W=2.5e-06 rf_flag=0
M388 VDD PULL_ON 65 VDD P L=1.8e-07 W=2.5e-06 rf_flag=0
M389 65 PULL_ON VDD VDD P L=1.8e-07 W=2.5e-06 rf_flag=0
M390 VDD PULL_ON 65 VDD P L=1.8e-07 W=2.5e-06 rf_flag=0
M391 65 PULL_ON VDD VDD P L=1.8e-07 W=2.5e-06 rf_flag=0
M392 VDD PULL_ON 65 VDD P L=1.8e-07 W=2.5e-06 rf_flag=0
M393 65 PULL_ON VDD VDD P L=1.8e-07 W=2.5e-06 rf_flag=0
M394 VDD PULL_UP_DOWN 65 VDD P L=1.8e-07 W=2.5e-06 rf_flag=0
M395 65 PULL_UP_DOWN VDD VDD P L=1.8e-07 W=2.5e-06 rf_flag=0
M396 VDD PULL_UP_DOWN 65 VDD P L=1.8e-07 W=2.5e-06 rf_flag=0
M397 65 PULL_UP_DOWN VDD VDD P L=1.8e-07 W=2.5e-06 rf_flag=0
M398 VDD PULL_UP_DOWN 65 VDD P L=1.8e-07 W=2.5e-06 rf_flag=0
M399 65 PULL_UP_DOWN VDD VDD P L=1.8e-07 W=2.5e-06 rf_flag=0
M400 VDD PULL_UP_DOWN 65 VDD P L=1.8e-07 W=2.5e-06 rf_flag=0
M401 65 PULL_UP_DOWN VDD VDD P L=1.8e-07 W=2.5e-06 rf_flag=0
M402 VDD DRIVE_STR 61 VDD P L=1.8e-07 W=2.5e-06 rf_flag=0
M403 61 DRIVE_STR VDD VDD P L=1.8e-07 W=2.5e-06 rf_flag=0
M404 VDD DRIVE_STR 61 VDD P L=1.8e-07 W=2.5e-06 rf_flag=0
M405 61 DRIVE_STR VDD VDD P L=1.8e-07 W=2.5e-06 rf_flag=0
M406 VDD 57 CIN VDD P L=1.8e-07 W=2.5e-06 rf_flag=0
M407 CIN 57 VDD VDD P L=1.8e-07 W=2.5e-06 rf_flag=0
M408 VDD 57 CIN VDD P L=1.8e-07 W=2.5e-06 rf_flag=0
M409 CIN 57 VDD VDD P L=1.8e-07 W=2.5e-06 rf_flag=0
M410 VDD 57 CIN VDD P L=1.8e-07 W=2.5e-06 rf_flag=0
M411 CIN 57 VDD VDD P L=1.8e-07 W=2.5e-06 rf_flag=0
M412 VDD 57 CIN VDD P L=1.8e-07 W=2.5e-06 rf_flag=0
M413 CIN 57 VDD VDD P L=1.8e-07 W=2.5e-06 rf_flag=0
M414 VDD VDD_OK 57 VDD P L=1.8e-07 W=2.5e-06 rf_flag=0
M415 57 VDD_OK VDD VDD P L=1.8e-07 W=2.5e-06 rf_flag=0
M416 VDD 74 57 VDD P L=1e-06 W=2.5e-06 rf_flag=0
M417 74 57 VDD VDD P L=1.8e-07 W=2.5e-06 rf_flag=0
M418 VDD 57 74 VDD P L=1.8e-07 W=2.5e-06 rf_flag=0
M419 VDD 65 70 VDD P L=1.8e-07 W=2.5e-06 rf_flag=0
M420 70 65 VDD VDD P L=1.8e-07 W=2.5e-06 rf_flag=0
M421 VDD 65 70 VDD P L=1.8e-07 W=2.5e-06 rf_flag=0
M422 70 65 VDD VDD P L=1.8e-07 W=2.5e-06 rf_flag=0
R423 22 VSSO 1180.47 L=2.65e-06 W=1e-06 postlayout=1 $SUB=VSSO $[RD3]
R424 PAD 59 307.767 L=2.9e-06 W=4e-06 postlayout=1 $SUB=VMAX $[RD3]
R425 59 52 307.767 L=2.9e-06 W=4e-06 postlayout=1 $SUB=VMAX $[RD3]
R426 VDDO 77 4491.62 L=1.3e-05 W=1e-06 postlayout=1 $SUB=VMAX $[RD3]
D427 VSS VDDO dwn2psub AREA=2.70045e-09 PJ=0.00056982
D428 VSS VDD dwn2psub AREA=1.02344e-09 PJ=0.00044015
D429 VSSO VDDO dwn2psub AREA=2.70045e-09 PJ=0.00056982
D430 VSS VDD dwn2psub AREA=1.02344e-09 PJ=0.00044015
D431 VSS VDDO dwn2psub AREA=6.3586e-10 PJ=0.00063586
D432 VSSO VDDO dwn2psub AREA=6.3586e-10 PJ=0.00063586
D433 VSS VMAX dwn2psub AREA=4.73188e-09 PJ=0.00032045
D434 VSSO PAD dnpwcpl5 AREA=4.2e-11 PJ=4.42e-05 nf=1
D435 VSSO PAD dnpwcpl5 AREA=4.2e-11 PJ=4.42e-05 nf=1
.ENDS

.SUBCKT PIOH_50_50 PAD VSSO VSS VDD VDDO SCHM_ON EN IE VDDO_OK I PULL_UP_DOWN PULL_ON TTL_ON DRIVE_STR VDD_OK CIN
*.PININFO PAD:B VSSO:B VSS:B VDD:B VDDO:B SCHM_ON:I EN:I IE:I VDDO_OK:I I:I PULL_UP_DOWN:I PULL_ON:I TTL_ON:I DRIVE_STR:I VDD_OK:I CIN:O
M0 78 VDDO_OK 7 VSSO N5 L=6e-07 W=5e-06 rf_flag=0
M1 7 VDDO_OK 78 VSSO N5 L=6e-07 W=5e-06 rf_flag=0
M2 78 VDDO_OK 7 VSSO N5 L=6e-07 W=5e-06 rf_flag=0
M3 7 VDDO_OK 78 VSSO N5 L=6e-07 W=5e-06 rf_flag=0
M4 VSS SCHM_ON 8 VSS N5 L=6e-07 W=2.5e-06 rf_flag=0
M5 78 8 VSSO VSSO N5 L=6e-07 W=5e-06 rf_flag=0
M6 VSSO 8 78 VSSO N5 L=6e-07 W=5e-06 rf_flag=0
M7 78 8 VSSO VSSO N5 L=6e-07 W=5e-06 rf_flag=0
M8 VSSO 8 78 VSSO N5 L=6e-07 W=5e-06 rf_flag=0
M9 39 7 VSSO VSSO N5 L=6e-07 W=5e-06 rf_flag=0
M10 VSSO 7 39 VSSO N5 L=6e-07 W=5e-06 rf_flag=0
M11 39 7 VSSO VSSO N5 L=6e-07 W=5e-06 rf_flag=0
M12 27 IE VSSO VSSO N5 L=6e-07 W=6.5e-06 rf_flag=0
M13 VSSO IE 27 VSSO N5 L=6e-07 W=6.5e-06 rf_flag=0
M14 13 VDDO_OK VSSO VSSO N5 L=6e-07 W=3.75e-06 rf_flag=0
M15 VSSO VDDO_OK 13 VSSO N5 L=6e-07 W=3.75e-06 rf_flag=0
M16 11 SCHM_ON VSSO VSSO N5 L=6e-07 W=4.34e-06 rf_flag=0
M17 VSSO SCHM_ON 11 VSSO N5 L=6e-07 W=4.34e-06 rf_flag=0
M18 11 SCHM_ON VSSO VSSO N5 L=6e-07 W=4.34e-06 rf_flag=0
M19 8 SCHM_ON VSS VSS N5 L=6e-07 W=2.5e-06 rf_flag=0
M20 17 VMAX VSSO VSSO N5 L=3e-06 W=5e-06 rf_flag=0
M21 20 IE VSS VSS N5 L=6e-07 W=2.5e-06 rf_flag=0
M22 VSS IE 20 VSS N5 L=6e-07 W=2.5e-06 rf_flag=0
M23 VSSO 19 18 VSSO N5 L=6e-07 W=3e-06 rf_flag=0
M24 19 VDDO_OK VSSO VSSO N5 L=6e-07 W=3e-06 rf_flag=0
M25 80 26 VSSO VSSO N5 L=6e-07 W=5e-06 rf_flag=0
M26 VSSO 26 80 VSSO N5 L=6e-07 W=5e-06 rf_flag=0
M27 80 26 VSSO VSSO N5 L=6e-07 W=5e-06 rf_flag=0
M28 VSSO 26 80 VSSO N5 L=6e-07 W=5e-06 rf_flag=0
M29 21 EN VSSO VSSO N5 L=6e-07 W=4.5e-06 rf_flag=0
M30 VSSO EN 21 VSSO N5 L=6e-07 W=4.5e-06 rf_flag=0
M31 34 18 VSSO VSSO N5 L=6e-07 W=5e-06 rf_flag=0
M32 VSSO 18 34 VSSO N5 L=6e-07 W=5e-06 rf_flag=0
M33 34 18 VSSO VSSO N5 L=6e-07 W=5e-06 rf_flag=0
M34 80 VDDO_OK 18 VSSO N5 L=6e-07 W=5e-06 rf_flag=0
M35 18 VDDO_OK 80 VSSO N5 L=6e-07 W=5e-06 rf_flag=0
M36 80 VDDO_OK 18 VSSO N5 L=6e-07 W=5e-06 rf_flag=0
M37 18 VDDO_OK 80 VSSO N5 L=6e-07 W=5e-06 rf_flag=0
M38 VSS EN 26 VSS N5 L=6e-07 W=2.5e-06 rf_flag=0
M39 32 20 VSSO VSSO N5 L=6e-07 W=5e-06 rf_flag=0
M40 VSSO 20 32 VSSO N5 L=6e-07 W=5e-06 rf_flag=0
M41 26 EN VSS VSS N5 L=6e-07 W=2.5e-06 rf_flag=0
M42 PAD 17 VSSO VSSO N5 L=6e-07 W=2.4e-05 rf_flag=0
M43 VSSO 14 PAD VSSO N5 L=6e-07 W=2.4e-05 rf_flag=0
M44 PAD 17 VSSO VSSO N5 L=6e-07 W=2.4e-05 rf_flag=0
M45 VSSO 14 PAD VSSO N5 L=6e-07 W=2.4e-05 rf_flag=0
M46 PAD 17 VSSO VSSO N5 L=6e-07 W=2.4e-05 rf_flag=0
M47 VSSO 14 PAD VSSO N5 L=6e-07 W=2.4e-05 rf_flag=0
M48 PAD 17 VSSO VSSO N5 L=6e-07 W=2.4e-05 rf_flag=0
M49 VSSO 15 PAD VSSO N5 L=6e-07 W=2.4e-05 rf_flag=0
M50 PAD 17 VSSO VSSO N5 L=6e-07 W=2.4e-05 rf_flag=0
M51 VSSO 15 PAD VSSO N5 L=6e-07 W=2.4e-05 rf_flag=0
M52 PAD 17 VSSO VSSO N5 L=6e-07 W=2.4e-05 rf_flag=0
M53 VSSO 15 PAD VSSO N5 L=6e-07 W=2.4e-05 rf_flag=0
M54 PAD 17 VSSO VSSO N5 L=6e-07 W=2.4e-05 rf_flag=0
M55 VSSO 16 PAD VSSO N5 L=6e-07 W=2.4e-05 rf_flag=0
M56 PAD 17 VSSO VSSO N5 L=6e-07 W=2.4e-05 rf_flag=0
M57 VSSO 16 PAD VSSO N5 L=6e-07 W=2.4e-05 rf_flag=0
M58 32 13 VSSO VSSO N5 L=6e-07 W=2e-06 rf_flag=0
M59 VSS EN 26 VSS N5 L=6e-07 W=2.5e-06 rf_flag=0
M60 VSSO 22 52 VSSO N5 L=6e-07 W=1e-05 rf_flag=0
M61 52 22 VSSO VSSO N5 L=6e-07 W=1e-05 rf_flag=0
M62 VSSO 24 52 VSSO N5 L=8e-06 W=1.5e-06 rf_flag=0
M63 54 23 VSSO VSSO N5 L=6e-07 W=1e-05 rf_flag=0
M64 VSSO 23 54 VSSO N5 L=6e-07 W=1e-05 rf_flag=0
M65 54 23 VSSO VSSO N5 L=6e-07 W=1e-05 rf_flag=0
M66 26 EN VSS VSS N5 L=6e-07 W=2.5e-06 rf_flag=0
M67 81 VDDO_OK 28 VSSO N5 L=6e-07 W=5e-06 rf_flag=0
M68 28 VDDO_OK 81 VSSO N5 L=6e-07 W=5e-06 rf_flag=0
M69 81 VDDO_OK 28 VSSO N5 L=6e-07 W=5e-06 rf_flag=0
M70 28 VDDO_OK 81 VSSO N5 L=6e-07 W=5e-06 rf_flag=0
M71 81 29 VSSO VSSO N5 L=6e-07 W=5e-06 rf_flag=0
M72 VSSO 29 81 VSSO N5 L=6e-07 W=5e-06 rf_flag=0
M73 81 29 VSSO VSSO N5 L=6e-07 W=5e-06 rf_flag=0
M74 VSSO 29 81 VSSO N5 L=6e-07 W=5e-06 rf_flag=0
M75 35 28 VSSO VSSO N5 L=6e-07 W=5e-06 rf_flag=0
M76 VSSO 28 35 VSSO N5 L=6e-07 W=5e-06 rf_flag=0
M77 35 28 VSSO VSSO N5 L=6e-07 W=5e-06 rf_flag=0
M78 VSS I 29 VSS N5 L=6e-07 W=2.5e-06 rf_flag=0
M79 31 I VSSO VSSO N5 L=6e-07 W=4.5e-06 rf_flag=0
M80 VSSO I 31 VSSO N5 L=6e-07 W=4.5e-06 rf_flag=0
M81 29 I VSS VSS N5 L=6e-07 W=2.5e-06 rf_flag=0
M82 51 32 VSSO VSSO N5 L=6e-07 W=3.75e-06 rf_flag=0
M83 VSSO 32 51 VSSO N5 L=6e-07 W=3.75e-06 rf_flag=0
M84 VSS I 29 VSS N5 L=6e-07 W=2.5e-06 rf_flag=0
M85 29 I VSS VSS N5 L=6e-07 W=2.5e-06 rf_flag=0
M86 VSS PULL_UP_DOWN 24 VSS N5 L=6e-07 W=3.75e-06 rf_flag=0
M87 VSSO 33 14 VSSO N5 L=6e-07 W=1.5e-05 rf_flag=0
M88 14 33 VSSO VSSO N5 L=6e-07 W=1.5e-05 rf_flag=0
M89 24 PULL_UP_DOWN VSS VSS N5 L=6e-07 W=3.75e-06 rf_flag=0
M90 VSSO 36 23 VSSO N5 L=6e-07 W=5e-06 rf_flag=0
M91 23 36 VSSO VSSO N5 L=6e-07 W=5e-06 rf_flag=0
M92 VSSO 36 23 VSSO N5 L=6e-07 W=5e-06 rf_flag=0
M93 23 35 VSSO VSSO N5 L=6e-07 W=5e-06 rf_flag=0
M94 VSSO 35 23 VSSO N5 L=6e-07 W=5e-06 rf_flag=0
M95 23 35 VSSO VSSO N5 L=6e-07 W=5e-06 rf_flag=0
M96 VSSO 34 23 VSSO N5 L=6e-07 W=5e-06 rf_flag=0
M97 23 34 VSSO VSSO N5 L=6e-07 W=5e-06 rf_flag=0
M98 VSSO 34 23 VSSO N5 L=6e-07 W=5e-06 rf_flag=0
M99 VSS PULL_UP_DOWN 24 VSS N5 L=6e-07 W=3.75e-06 rf_flag=0
M100 24 PULL_UP_DOWN VSS VSS N5 L=6e-07 W=3.75e-06 rf_flag=0
M101 76 38 75 VSSO N5 L=6e-07 W=1e-05 rf_flag=0
M102 75 38 76 VSSO N5 L=6e-07 W=1e-05 rf_flag=0
M103 76 38 75 VSSO N5 L=6e-07 W=1e-05 rf_flag=0
M104 54 23 76 VSSO N5 L=6e-07 W=1e-05 rf_flag=0
M105 76 23 54 VSSO N5 L=6e-07 W=1e-05 rf_flag=0
M106 54 23 76 VSSO N5 L=6e-07 W=1e-05 rf_flag=0
M107 VSS 42 24 VSS N5 L=6e-07 W=3.75e-06 rf_flag=0
M108 24 42 VSS VSS N5 L=6e-07 W=3.75e-06 rf_flag=0
M109 VSS 42 24 VSS N5 L=6e-07 W=3.75e-06 rf_flag=0
M110 24 42 VSS VSS N5 L=6e-07 W=3.75e-06 rf_flag=0
M111 VSSO 40 36 VSSO N5 L=6e-07 W=5e-06 rf_flag=0
M112 36 40 VSSO VSSO N5 L=6e-07 W=5e-06 rf_flag=0
M113 VSSO 41 16 VSSO N5 L=6e-07 W=7.5e-06 rf_flag=0
M114 16 41 VSSO VSSO N5 L=6e-07 W=7.5e-06 rf_flag=0
M115 VSSO 41 15 VSSO N5 L=6e-07 W=7.5e-06 rf_flag=0
M116 15 41 VSSO VSSO N5 L=6e-07 W=7.5e-06 rf_flag=0
M117 VSSO 39 43 VSSO N5 L=6e-07 W=5e-06 rf_flag=0
M118 44 46 VSSO VSSO N5 L=6e-07 W=5e-06 rf_flag=0
M119 42 PULL_ON VSS VSS N5 L=6e-07 W=3.5e-06 rf_flag=0
M120 85 44 VSSO VSSO N5 L=6e-07 W=2e-06 rf_flag=0
M121 46 43 85 VSSO N5 L=6e-07 W=1.3e-06 rf_flag=0
M122 VSS PULL_ON 42 VSS N5 L=6e-07 W=3.5e-06 rf_flag=0
M123 VSSO 16 40 VSSO N5 L=6e-07 W=5e-06 rf_flag=0
M124 56 48 VSSO VSSO N5 L=6e-07 W=1e-05 rf_flag=0
M125 46 TTL_ON 89 VSSO N5 L=6e-07 W=8.335e-06 rf_flag=0
M126 89 TTL_ON 46 VSSO N5 L=6e-07 W=8.335e-06 rf_flag=0
M127 46 TTL_ON 89 VSSO N5 L=6e-07 W=8.335e-06 rf_flag=0
M128 VSS PULL_ON 87 VSS N5 L=6e-07 W=3.5e-06 rf_flag=0
M129 87 PULL_ON VSS VSS N5 L=6e-07 W=3.5e-06 rf_flag=0
M130 65 PULL_UP_DOWN 87 VSS N5 L=6e-07 W=3.5e-06 rf_flag=0
M131 VSSO 50 38 VSSO N5 L=6e-07 W=1e-05 rf_flag=0
M132 38 50 VSSO VSSO N5 L=6e-07 W=1e-05 rf_flag=0
M133 87 PULL_UP_DOWN 65 VSS N5 L=6e-07 W=3.5e-06 rf_flag=0
M134 91 49 VSSO VSSO N5 L=6e-07 W=1e-05 rf_flag=0
M135 VSSO 49 91 VSSO N5 L=6e-07 W=1e-05 rf_flag=0
M136 91 52 89 VSSO N5 L=6e-07 W=8.335e-06 rf_flag=0
M137 89 52 91 VSSO N5 L=6e-07 W=8.335e-06 rf_flag=0
M138 91 52 89 VSSO N5 L=6e-07 W=8.335e-06 rf_flag=0
M139 VSSO 23 90 VSSO N5 L=6e-07 W=5e-06 rf_flag=0
M140 90 23 VSSO VSSO N5 L=6e-07 W=5e-06 rf_flag=0
M141 50 53 90 VSSO N5 L=6e-07 W=5e-06 rf_flag=0
M142 90 53 50 VSSO N5 L=6e-07 W=5e-06 rf_flag=0
M143 48 54 VSSO VSSO N5 L=6e-07 W=5e-06 rf_flag=0
M144 VSS DRIVE_STR 61 VSS N5 L=6e-07 W=5e-06 rf_flag=0
M145 46 52 91 VSSO N5 L=6e-07 W=5e-06 rf_flag=0
M146 61 DRIVE_STR VSS VSS N5 L=6e-07 W=5e-06 rf_flag=0
M147 CIN 57 VSS VSS N5 L=6e-07 W=5e-06 rf_flag=0
M148 VSS 57 CIN VSS N5 L=6e-07 W=5e-06 rf_flag=0
M149 92 58 VSSO VSSO N5 L=6e-07 W=1.5e-05 rf_flag=0
M150 93 35 92 VSSO N5 L=6e-07 W=1.5e-05 rf_flag=0
M151 41 56 93 VSSO N5 L=6e-07 W=1.5e-05 rf_flag=0
M152 CIN 57 VSS VSS N5 L=6e-07 W=5e-06 rf_flag=0
M153 95 VDDO_OK 60 VSSO N5 L=6e-07 W=5e-06 rf_flag=0
M154 60 VDDO_OK 95 VSSO N5 L=6e-07 W=5e-06 rf_flag=0
M155 95 VDDO_OK 60 VSSO N5 L=6e-07 W=5e-06 rf_flag=0
M156 60 VDDO_OK 95 VSSO N5 L=6e-07 W=5e-06 rf_flag=0
M157 95 61 VSSO VSSO N5 L=6e-07 W=5e-06 rf_flag=0
M158 VSSO 61 95 VSSO N5 L=6e-07 W=5e-06 rf_flag=0
M159 95 61 VSSO VSSO N5 L=6e-07 W=5e-06 rf_flag=0
M160 VSSO 61 95 VSSO N5 L=6e-07 W=5e-06 rf_flag=0
M161 72 60 VSSO VSSO N5 L=6e-07 W=5e-06 rf_flag=0
M162 VSSO 60 72 VSSO N5 L=6e-07 W=5e-06 rf_flag=0
M163 72 60 VSSO VSSO N5 L=6e-07 W=5e-06 rf_flag=0
M164 62 DRIVE_STR VSSO VSSO N5 L=6e-07 W=4.5e-06 rf_flag=0
M165 VSSO DRIVE_STR 62 VSSO N5 L=6e-07 W=4.5e-06 rf_flag=0
M166 49 51 VSSO VSSO N5 L=6e-07 W=3.75e-06 rf_flag=0
M167 VSSO 51 49 VSSO N5 L=6e-07 W=3.75e-06 rf_flag=0
M168 96 VDD_OK 57 VSS N5 L=6e-07 W=7e-06 rf_flag=0
M169 57 VDD_OK 96 VSS N5 L=6e-07 W=7e-06 rf_flag=0
M170 96 VDD_OK 57 VSS N5 L=6e-07 W=7e-06 rf_flag=0
M171 67 70 VSSO VSSO N5 L=6e-07 W=5e-06 rf_flag=0
M172 VSSO 70 67 VSSO N5 L=6e-07 W=5e-06 rf_flag=0
M173 67 70 VSSO VSSO N5 L=6e-07 W=5e-06 rf_flag=0
M174 VSSO 70 67 VSSO N5 L=6e-07 W=5e-06 rf_flag=0
M175 69 65 VSSO VSSO N5 L=6e-07 W=4.5e-06 rf_flag=0
M176 VSSO 65 69 VSSO N5 L=6e-07 W=4.5e-06 rf_flag=0
M177 64 67 VSSO VSSO N5 L=6e-07 W=5e-06 rf_flag=0
M178 VSSO 67 64 VSSO N5 L=6e-07 W=5e-06 rf_flag=0
M179 64 67 VSSO VSSO N5 L=6e-07 W=5e-06 rf_flag=0
M180 57 VDD_OK 96 VSS N5 L=6e-07 W=7e-06 rf_flag=0
M181 96 VDD_OK 57 VSS N5 L=6e-07 W=7e-06 rf_flag=0
M182 VSS 73 96 VSS N5 L=6e-07 W=7e-06 rf_flag=0
M183 96 73 VSS VSS N5 L=6e-07 W=7e-06 rf_flag=0
M184 VSS 73 96 VSS N5 L=6e-07 W=7e-06 rf_flag=0
M185 96 73 VSS VSS N5 L=6e-07 W=7e-06 rf_flag=0
M186 VSSO 64 63 VSSO N5 L=6e-07 W=5e-06 rf_flag=0
M187 73 46 VSSO VSSO N5 L=6e-07 W=5e-06 rf_flag=0
M188 VSSO 46 73 VSSO N5 L=6e-07 W=5e-06 rf_flag=0
M189 VSS 73 96 VSS N5 L=6e-07 W=7e-06 rf_flag=0
M190 VSSO 72 53 VSSO N5 L=6e-07 W=7.5e-06 rf_flag=0
M191 53 72 VSSO VSSO N5 L=6e-07 W=7.5e-06 rf_flag=0
M192 VSSO 71 33 VSSO N5 L=6e-07 W=7.5e-06 rf_flag=0
M193 33 71 VSSO VSSO N5 L=6e-07 W=7.5e-06 rf_flag=0
M194 VSSO 34 58 VSSO N5 L=6e-07 W=7.5e-06 rf_flag=0
M195 58 34 VSSO VSSO N5 L=6e-07 W=7.5e-06 rf_flag=0
M196 VSS 46 74 VSS N5 L=6e-07 W=4.5e-06 rf_flag=0
M197 71 72 VSSO VSSO N5 L=6e-07 W=5e-06 rf_flag=0
M198 VSSO 72 71 VSSO N5 L=6e-07 W=5e-06 rf_flag=0
M199 71 41 VSSO VSSO N5 L=6e-07 W=5e-06 rf_flag=0
M200 VSSO 41 71 VSSO N5 L=6e-07 W=5e-06 rf_flag=0
M201 68 58 VSSO VSSO N5 L=6e-07 W=5e-06 rf_flag=0
M202 VSSO 58 68 VSSO N5 L=6e-07 W=5e-06 rf_flag=0
M203 74 46 VSS VSS N5 L=6e-07 W=4.5e-06 rf_flag=0
M204 VSS 65 70 VSS N5 L=6e-07 W=5e-06 rf_flag=0
M205 70 65 VSS VSS N5 L=6e-07 W=5e-06 rf_flag=0
M206 VDD SCHM_ON 8 VDD P5 L=5e-07 W=2.5e-06 rf_flag=0
M207 8 SCHM_ON VDD VDD P5 L=5e-07 W=2.5e-06 rf_flag=0
M208 13 VDDO_OK VDDO VDDO P5 L=5e-07 W=5e-06 rf_flag=0
M209 VDDO VDDO_OK 13 VDDO P5 L=5e-07 W=5e-06 rf_flag=0
M210 39 7 VDDO VDDO P5 L=5e-07 W=5.01e-06 rf_flag=0
M211 VDDO 7 39 VDDO P5 L=5e-07 W=5.01e-06 rf_flag=0
M212 39 7 VDDO VDDO P5 L=5e-07 W=5.01e-06 rf_flag=0
M213 VDDO 7 39 VDDO P5 L=5e-07 W=5.01e-06 rf_flag=0
M214 VDD SCHM_ON 8 VDD P5 L=5e-07 W=2.5e-06 rf_flag=0
M215 8 SCHM_ON VDD VDD P5 L=5e-07 W=2.5e-06 rf_flag=0
M216 7 11 VDDO VDDO P5 L=5e-07 W=2.5e-06 rf_flag=0
M217 VDDO 11 7 VDDO P5 L=5e-07 W=2.5e-06 rf_flag=0
M218 7 VDDO_OK VDDO VDDO P5 L=5e-07 W=2.5e-06 rf_flag=0
M219 VDDO VDDO_OK 7 VDDO P5 L=5e-07 W=2.5e-06 rf_flag=0
M220 11 7 VDDO VDDO P5 L=5e-07 W=2e-06 rf_flag=0
M221 20 IE VDD VDD P5 L=5e-07 W=3.335e-06 rf_flag=0
M222 VDD IE 20 VDD P5 L=5e-07 W=3.335e-06 rf_flag=0
M223 18 21 VDDO VDDO P5 L=5e-07 W=2.5e-06 rf_flag=0
M224 VDDO 21 18 VDDO P5 L=5e-07 W=2.5e-06 rf_flag=0
M225 19 VDDO_OK VDDO VDDO P5 L=5e-07 W=2.5e-06 rf_flag=0
M226 VDDO VDDO_OK 19 VDDO P5 L=5e-07 W=2.5e-06 rf_flag=0
M227 21 18 VDDO VDDO P5 L=5e-07 W=2e-06 rf_flag=0
M228 34 18 VDDO VDDO P5 L=5e-07 W=5e-06 rf_flag=0
M229 VDDO 18 34 VDDO P5 L=5e-07 W=5e-06 rf_flag=0
M230 34 18 VDDO VDDO P5 L=5e-07 W=5e-06 rf_flag=0
M231 VDDO 18 34 VDDO P5 L=5e-07 W=5e-06 rf_flag=0
M232 79 27 32 VDDO P5 L=5e-07 W=5e-06 rf_flag=0
M233 VDDO 13 79 VDDO P5 L=5e-07 W=5e-06 rf_flag=0
M234 79 13 VDDO VDDO P5 L=5e-07 W=5e-06 rf_flag=0
M235 VDDO 13 79 VDDO P5 L=5e-07 W=5e-06 rf_flag=0
M236 20 IE VDD VDD P5 L=5e-07 W=3.335e-06 rf_flag=0
M237 VDD EN 26 VDD P5 L=5e-07 W=2.5e-06 rf_flag=0
M238 26 EN VDD VDD P5 L=5e-07 W=2.5e-06 rf_flag=0
M239 VDD EN 26 VDD P5 L=5e-07 W=2.5e-06 rf_flag=0
M240 26 EN VDD VDD P5 L=5e-07 W=2.5e-06 rf_flag=0
M241 VDDO 32 27 VDDO P5 L=5e-07 W=2e-06 rf_flag=0
M242 35 28 VDDO VDDO P5 L=5e-07 W=5e-06 rf_flag=0
M243 VDDO 28 35 VDDO P5 L=5e-07 W=5e-06 rf_flag=0
M244 35 28 VDDO VDDO P5 L=5e-07 W=5e-06 rf_flag=0
M245 VDDO 28 35 VDDO P5 L=5e-07 W=5e-06 rf_flag=0
M246 VDD I 29 VDD P5 L=5e-07 W=2.5e-06 rf_flag=0
M247 29 I VDD VDD P5 L=5e-07 W=2.5e-06 rf_flag=0
M248 28 31 VDDO VDDO P5 L=5e-07 W=2.5e-06 rf_flag=0
M249 VDDO 31 28 VDDO P5 L=5e-07 W=2.5e-06 rf_flag=0
M250 28 VDDO_OK VDDO VDDO P5 L=5e-07 W=2.5e-06 rf_flag=0
M251 VDDO VDDO_OK 28 VDDO P5 L=5e-07 W=2.5e-06 rf_flag=0
M252 51 32 VDDO VDDO P5 L=5e-07 W=5e-06 rf_flag=0
M253 VDDO 32 51 VDDO P5 L=5e-07 W=5e-06 rf_flag=0
M254 VDD I 29 VDD P5 L=5e-07 W=2.5e-06 rf_flag=0
M255 31 28 VDDO VDDO P5 L=5e-07 W=2e-06 rf_flag=0
M256 29 I VDD VDD P5 L=5e-07 W=2.5e-06 rf_flag=0
M257 24 PULL_UP_DOWN 84 VDD P5 L=5e-07 W=2e-06 rf_flag=0
M258 43 39 VDDO VDDO P5 L=5e-07 W=6e-06 rf_flag=0
M259 82 34 23 VDDO P5 L=5e-07 W=5e-06 rf_flag=0
M260 23 34 82 VDDO P5 L=5e-07 W=5e-06 rf_flag=0
M261 82 34 23 VDDO P5 L=5e-07 W=5e-06 rf_flag=0
M262 83 35 82 VDDO P5 L=5e-07 W=5e-06 rf_flag=0
M263 82 35 83 VDDO P5 L=5e-07 W=5e-06 rf_flag=0
M264 83 35 82 VDDO P5 L=5e-07 W=5e-06 rf_flag=0
M265 VDDO 36 83 VDDO P5 L=5e-07 W=5e-06 rf_flag=0
M266 83 36 VDDO VDDO P5 L=5e-07 W=5e-06 rf_flag=0
M267 VDDO 36 83 VDDO P5 L=5e-07 W=5e-06 rf_flag=0
M268 84 PULL_UP_DOWN 24 VDD P5 L=5e-07 W=2e-06 rf_flag=0
M269 24 PULL_UP_DOWN 84 VDD P5 L=5e-07 W=2e-06 rf_flag=0
M270 84 PULL_UP_DOWN 24 VDD P5 L=5e-07 W=2e-06 rf_flag=0
M271 VDD 42 84 VDD P5 L=5e-07 W=2e-06 rf_flag=0
M272 84 42 VDD VDD P5 L=5e-07 W=2e-06 rf_flag=0
M273 VDD 42 84 VDD P5 L=5e-07 W=2e-06 rf_flag=0
M274 84 42 VDD VDD P5 L=5e-07 W=2e-06 rf_flag=0
M275 15 33 14 VDDO P5 L=5e-07 W=1e-05 rf_flag=0
M276 14 33 15 VDDO P5 L=5e-07 W=1e-05 rf_flag=0
M277 15 33 14 VDDO P5 L=5e-07 W=1e-05 rf_flag=0
M278 16 41 15 VDDO P5 L=5e-07 W=1e-05 rf_flag=0
M279 15 41 16 VDDO P5 L=5e-07 W=1e-05 rf_flag=0
M280 16 41 15 VDDO P5 L=5e-07 W=1e-05 rf_flag=0
M281 VDDO 41 16 VDDO P5 L=5e-07 W=1e-05 rf_flag=0
M282 16 41 VDDO VDDO P5 L=5e-07 W=1e-05 rf_flag=0
M283 VDDO 41 16 VDDO P5 L=5e-07 W=1e-05 rf_flag=0
M284 VDDO 40 36 VDDO P5 L=5e-07 W=7.5e-06 rf_flag=0
M285 36 40 VDDO VDDO P5 L=5e-07 W=7.5e-06 rf_flag=0
M286 42 PULL_ON VDD VDD P5 L=5e-07 W=2.5e-06 rf_flag=0
M287 40 16 VDDO VDDO P5 L=5e-07 W=7.5e-06 rf_flag=0
M288 VDD PULL_ON 42 VDD P5 L=5e-07 W=2.5e-06 rf_flag=0
M289 VDDO 44 86 VDDO P5 L=5e-07 W=5e-06 rf_flag=0
M290 42 PULL_ON VDD VDD P5 L=5e-07 W=2.5e-06 rf_flag=0
M291 VDD PULL_ON 42 VDD P5 L=5e-07 W=2.5e-06 rf_flag=0
M292 VDD PULL_ON 65 VDD P5 L=5e-07 W=2.5e-06 rf_flag=0
M293 65 PULL_ON VDD VDD P5 L=5e-07 W=2.5e-06 rf_flag=0
M294 VDD PULL_ON 65 VDD P5 L=5e-07 W=2.5e-06 rf_flag=0
M295 65 PULL_ON VDD VDD P5 L=5e-07 W=2.5e-06 rf_flag=0
M296 VDD PULL_ON 65 VDD P5 L=5e-07 W=2.5e-06 rf_flag=0
M297 VDDO 54 48 VDDO P5 L=5e-07 W=7.5e-06 rf_flag=0
M298 56 48 VDDO VDDO P5 L=5e-07 W=7.5e-06 rf_flag=0
M299 VDDO 48 56 VDDO P5 L=5e-07 W=7.5e-06 rf_flag=0
M300 65 PULL_ON VDD VDD P5 L=5e-07 W=2.5e-06 rf_flag=0
M301 46 49 VDDO VDDO P5 L=5e-07 W=5e-06 rf_flag=0
M302 VDD PULL_ON 65 VDD P5 L=5e-07 W=2.5e-06 rf_flag=0
M303 86 39 46 VDDO P5 L=5e-07 W=2.7e-06 rf_flag=0
M304 65 PULL_ON VDD VDD P5 L=5e-07 W=2.5e-06 rf_flag=0
M305 88 52 46 VDDO P5 L=5e-07 W=1e-05 rf_flag=0
M306 88 51 VDDO VDDO P5 L=5e-07 W=1e-05 rf_flag=0
M307 VDDO 51 88 VDDO P5 L=5e-07 W=1e-05 rf_flag=0
M308 44 46 VDDO VDDO P5 L=5e-07 W=1e-05 rf_flag=0
M309 VDD PULL_UP_DOWN 65 VDD P5 L=5e-07 W=2.5e-06 rf_flag=0
M310 65 PULL_UP_DOWN VDD VDD P5 L=5e-07 W=2.5e-06 rf_flag=0
M311 VDD PULL_UP_DOWN 65 VDD P5 L=5e-07 W=2.5e-06 rf_flag=0
M312 65 PULL_UP_DOWN VDD VDD P5 L=5e-07 W=2.5e-06 rf_flag=0
M313 50 53 VDDO VDDO P5 L=5e-07 W=7.5e-06 rf_flag=0
M314 VDDO 23 50 VDDO P5 L=5e-07 W=7.5e-06 rf_flag=0
M315 VDD PULL_UP_DOWN 65 VDD P5 L=5e-07 W=2.5e-06 rf_flag=0
M316 65 PULL_UP_DOWN VDD VDD P5 L=5e-07 W=2.5e-06 rf_flag=0
M317 38 50 VDDO VDDO P5 L=5e-07 W=5e-06 rf_flag=0
M318 VDDO 50 38 VDDO P5 L=5e-07 W=5e-06 rf_flag=0
M319 38 50 VDDO VDDO P5 L=5e-07 W=5e-06 rf_flag=0
M320 VDD PULL_UP_DOWN 65 VDD P5 L=5e-07 W=2.5e-06 rf_flag=0
M321 VMAX 38 75 VMAX P5 L=5e-07 W=1e-05 rf_flag=0
M322 75 38 VMAX VMAX P5 L=5e-07 W=1e-05 rf_flag=0
M323 65 PULL_UP_DOWN VDD VDD P5 L=5e-07 W=2.5e-06 rf_flag=0
M324 76 23 VMAX VMAX P5 L=5e-07 W=1e-05 rf_flag=0
M325 PAD 75 VDDO VMAX P5 L=5e-07 W=2.08e-05 rf_flag=0
M326 VDDO 75 PAD VMAX P5 L=5e-07 W=2.08e-05 rf_flag=0
M327 PAD 75 VDDO VMAX P5 L=5e-07 W=2.08e-05 rf_flag=0
M328 VDDO 75 PAD VMAX P5 L=5e-07 W=2.08e-05 rf_flag=0
M329 PAD 75 VDDO VMAX P5 L=5e-07 W=2.08e-05 rf_flag=0
M330 VDDO 75 PAD VMAX P5 L=5e-07 W=2.08e-05 rf_flag=0
M331 PAD 75 VDDO VMAX P5 L=5e-07 W=2.08e-05 rf_flag=0
M332 VDDO 75 PAD VMAX P5 L=5e-07 W=2.08e-05 rf_flag=0
M333 PAD 75 VDDO VMAX P5 L=5e-07 W=2.08e-05 rf_flag=0
M334 VDDO 75 PAD VMAX P5 L=5e-07 W=2.08e-05 rf_flag=0
M335 PAD 76 VDDO VMAX P5 L=5e-07 W=2.08e-05 rf_flag=0
M336 VDDO 76 PAD VMAX P5 L=5e-07 W=2.08e-05 rf_flag=0
M337 PAD 76 VDDO VMAX P5 L=5e-07 W=2.08e-05 rf_flag=0
M338 VDDO 76 PAD VMAX P5 L=5e-07 W=2.08e-05 rf_flag=0
M339 PAD 76 VDDO VMAX P5 L=5e-07 W=2.08e-05 rf_flag=0
M340 VDDO 76 PAD VMAX P5 L=5e-07 W=2.08e-05 rf_flag=0
M341 PAD 54 VDDO VMAX P5 L=5e-07 W=2.08e-05 rf_flag=0
M342 VDDO 54 PAD VMAX P5 L=5e-07 W=2.08e-05 rf_flag=0
M343 PAD 54 VDDO VMAX P5 L=5e-07 W=2.08e-05 rf_flag=0
M344 VDDO 54 PAD VMAX P5 L=5e-07 W=2.08e-05 rf_flag=0
M345 VDD DRIVE_STR 61 VDD P5 L=5e-07 W=2.5e-06 rf_flag=0
M346 61 DRIVE_STR VDD VDD P5 L=5e-07 W=2.5e-06 rf_flag=0
M347 VMAX 23 54 VMAX P5 L=5e-07 W=6e-06 rf_flag=0
M348 VDDO 51 49 VDDO P5 L=5e-07 W=1e-05 rf_flag=0
M349 VDD DRIVE_STR 61 VDD P5 L=5e-07 W=2.5e-06 rf_flag=0
M350 VMAX 58 41 VMAX P5 L=5e-07 W=7.5e-06 rf_flag=0
M351 41 58 VMAX VMAX P5 L=5e-07 W=7.5e-06 rf_flag=0
M352 VMAX 35 41 VMAX P5 L=5e-07 W=7.5e-06 rf_flag=0
M353 41 35 VMAX VMAX P5 L=5e-07 W=7.5e-06 rf_flag=0
M354 VMAX 56 41 VMAX P5 L=5e-07 W=7.5e-06 rf_flag=0
M355 41 56 VMAX VMAX P5 L=5e-07 W=7.5e-06 rf_flag=0
M356 63 64 VMAX VMAX P5 L=5e-07 W=7e-06 rf_flag=0
M357 61 DRIVE_STR VDD VDD P5 L=5e-07 W=2.5e-06 rf_flag=0
M358 72 60 VDDO VDDO P5 L=5e-07 W=5e-06 rf_flag=0
M359 VDDO 60 72 VDDO P5 L=5e-07 W=5e-06 rf_flag=0
M360 72 60 VDDO VDDO P5 L=5e-07 W=5e-06 rf_flag=0
M361 VDDO 60 72 VDDO P5 L=5e-07 W=5e-06 rf_flag=0
M362 VDD 57 CIN VDD P5 L=5e-07 W=2.5e-06 rf_flag=0
M363 60 62 VDDO VDDO P5 L=5e-07 W=2.5e-06 rf_flag=0
M364 VDDO 62 60 VDDO P5 L=5e-07 W=2.5e-06 rf_flag=0
M365 60 VDDO_OK VDDO VDDO P5 L=5e-07 W=2.5e-06 rf_flag=0
M366 VDDO VDDO_OK 60 VDDO P5 L=5e-07 W=2.5e-06 rf_flag=0
M367 CIN 57 VDD VDD P5 L=5e-07 W=2.5e-06 rf_flag=0
M368 62 60 VDDO VDDO P5 L=5e-07 W=2e-06 rf_flag=0
M369 VDD 57 CIN VDD P5 L=5e-07 W=2.5e-06 rf_flag=0
M370 CIN 57 VDD VDD P5 L=5e-07 W=2.5e-06 rf_flag=0
M371 VDDO 63 52 VMAX P5 L=4e-06 W=2.5e-06 rf_flag=0
M372 VDD 57 CIN VDD P5 L=5e-07 W=2.5e-06 rf_flag=0
M373 67 69 VDDO VDDO P5 L=5e-07 W=2.5e-06 rf_flag=0
M374 VDDO 69 67 VDDO P5 L=5e-07 W=2.5e-06 rf_flag=0
M375 69 67 VDDO VDDO P5 L=5e-07 W=2e-06 rf_flag=0
M376 64 67 VDDO VDDO P5 L=5e-07 W=5e-06 rf_flag=0
M377 VDDO 67 64 VDDO P5 L=5e-07 W=5e-06 rf_flag=0
M378 64 67 VDDO VDDO P5 L=5e-07 W=5e-06 rf_flag=0
M379 VDDO 67 64 VDDO P5 L=5e-07 W=5e-06 rf_flag=0
M380 CIN 57 VDD VDD P5 L=5e-07 W=2.5e-06 rf_flag=0
M381 VDD 57 CIN VDD P5 L=5e-07 W=2.5e-06 rf_flag=0
M382 VDDO VMAX VMAX VMAX P5 L=5e-07 W=1.5e-05 rf_flag=0
M383 VMAX VMAX VDDO VMAX P5 L=5e-07 W=1.5e-05 rf_flag=0
M384 VDDO VMAX VMAX VMAX P5 L=5e-07 W=1.5e-05 rf_flag=0
M385 VMAX VMAX VDDO VMAX P5 L=5e-07 W=1.5e-05 rf_flag=0
M386 VMAX 52 VDDO VMAX P5 L=5e-07 W=1.5e-05 rf_flag=0
M387 52 77 VMAX VMAX P5 L=5e-07 W=1.5e-05 rf_flag=0
M388 CIN 57 VDD VDD P5 L=5e-07 W=2.5e-06 rf_flag=0
M389 VDDO 68 VMAX VMAX P5 L=5e-07 W=1.5e-05 rf_flag=0
M390 VMAX 68 VDDO VMAX P5 L=5e-07 W=1.5e-05 rf_flag=0
M391 VDDO 68 VMAX VMAX P5 L=5e-07 W=1.5e-05 rf_flag=0
M392 VMAX 68 VDDO VMAX P5 L=5e-07 W=1.5e-05 rf_flag=0
M393 VDDO 68 VMAX VMAX P5 L=5e-07 W=1.5e-05 rf_flag=0
M394 VMAX 68 VDDO VMAX P5 L=5e-07 W=1.5e-05 rf_flag=0
M395 VDDO 68 VMAX VMAX P5 L=5e-07 W=1.5e-05 rf_flag=0
M396 VMAX 68 VDDO VMAX P5 L=5e-07 W=1.5e-05 rf_flag=0
M397 VDDO 68 VMAX VMAX P5 L=5e-07 W=1.5e-05 rf_flag=0
M398 VMAX 68 VDDO VMAX P5 L=5e-07 W=1.5e-05 rf_flag=0
M399 VDDO 68 VMAX VMAX P5 L=5e-07 W=1.5e-05 rf_flag=0
M400 VMAX 68 VDDO VMAX P5 L=5e-07 W=1.5e-05 rf_flag=0
M401 VDDO 46 73 VDDO P5 L=5e-07 W=5e-06 rf_flag=0
M402 73 46 VDDO VDDO P5 L=5e-07 W=5e-06 rf_flag=0
M403 VDD VDD_OK 57 VDD P5 L=5e-07 W=2.5e-06 rf_flag=0
M404 57 VDD_OK VDD VDD P5 L=5e-07 W=2.5e-06 rf_flag=0
M405 VMAX 71 33 VMAX P5 L=5e-07 W=1e-05 rf_flag=0
M406 33 71 VMAX VMAX P5 L=5e-07 W=1e-05 rf_flag=0
M407 VDDO 34 58 VDDO P5 L=5e-07 W=7.5e-06 rf_flag=0
M408 58 34 VDDO VDDO P5 L=5e-07 W=7.5e-06 rf_flag=0
M409 VMAX 58 68 VMAX P5 L=5e-07 W=1e-05 rf_flag=0
M410 VDDO 72 97 VDDO P5 L=5e-07 W=7.5e-06 rf_flag=0
M411 97 72 VDDO VDDO P5 L=5e-07 W=7.5e-06 rf_flag=0
M412 71 41 97 VDDO P5 L=5e-07 W=7.5e-06 rf_flag=0
M413 97 41 71 VDDO P5 L=5e-07 W=7.5e-06 rf_flag=0
M414 VDDO 72 53 VDDO P5 L=5e-07 W=6e-06 rf_flag=0
M415 53 72 VDDO VDDO P5 L=5e-07 W=6e-06 rf_flag=0
M416 VDD 74 57 VDD P5 L=1e-06 W=2.5e-06 rf_flag=0
M417 74 57 VDD VDD P5 L=6e-07 W=2.5e-06 rf_flag=0
M418 VDD 57 74 VDD P5 L=6e-07 W=2.5e-06 rf_flag=0
M419 VDD 65 70 VDD P5 L=5e-07 W=2.5e-06 rf_flag=0
M420 70 65 VDD VDD P5 L=5e-07 W=2.5e-06 rf_flag=0
M421 VDD 65 70 VDD P5 L=5e-07 W=2.5e-06 rf_flag=0
M422 70 65 VDD VDD P5 L=5e-07 W=2.5e-06 rf_flag=0
R423 22 VSSO 1180.47 L=2.65e-06 W=1e-06 postlayout=1 $SUB=VSSO $[RD3]
R424 PAD 59 307.767 L=2.9e-06 W=4e-06 postlayout=1 $SUB=VMAX $[RD3]
R425 59 52 307.767 L=2.9e-06 W=4e-06 postlayout=1 $SUB=VMAX $[RD3]
R426 VDDO 77 4491.62 L=1.3e-05 W=1e-06 postlayout=1 $SUB=VMAX $[RD3]
D427 VSS VDDO dwn2psub AREA=2.70045e-09 PJ=0.00056982
D428 VSS VDD dwn2psub AREA=1.02344e-09 PJ=0.00044015
D429 VSSO VDDO dwn2psub AREA=2.70045e-09 PJ=0.00056982
D430 VSS VDD dwn2psub AREA=1.02344e-09 PJ=0.00044015
D431 VSS VDDO dwn2psub AREA=6.3586e-10 PJ=0.00063586
D432 VSSO VDDO dwn2psub AREA=6.3586e-10 PJ=0.00063586
D433 VSS VMAX dwn2psub AREA=4.73188e-09 PJ=0.00032045
D434 VSSO PAD dnpwcpl5 AREA=4.2e-11 PJ=4.42e-05 nf=1
D435 VSSO PAD dnpwcpl5 AREA=4.2e-11 PJ=4.42e-05 nf=1
.ENDS

.SUBCKT PIOHO_50_18 PAD VSSO VDDO VSS VDD SCHM_ON EN IE I VDDO_OK PULL_UP_DOWN PULL_ON TTL_ON DRIVE_STR VDD_OK CIN
*.PININFO PAD:B VSSO:B VDDO:B VSS:B VDD:B SCHM_ON:I EN:I IE:I I:I VDDO_OK:I PULL_UP_DOWN:I PULL_ON:I TTL_ON:I DRIVE_STR:I VDD_OK:I CIN:O
M0 94 22 8 VSSO N5 L=6e-07 W=1e-05 rf_flag=0
M1 8 10 9 VSSO N5 L=6e-07 W=1.0005e-05 rf_flag=0
M2 9 10 8 VSSO N5 L=6e-07 W=1.0005e-05 rf_flag=0
M3 VSSO 11 62 VSSO N5 L=6e-07 W=1.5e-05 rf_flag=0
M4 62 11 VSSO VSSO N5 L=6e-07 W=1.5e-05 rf_flag=0
M5 97 11 62 VSSO N5 L=6e-07 W=1.5e-05 rf_flag=0
M6 62 11 97 VSSO N5 L=6e-07 W=1.5e-05 rf_flag=0
M7 99 28 97 VSSO N5 L=6e-07 W=1.5e-05 rf_flag=0
M8 97 28 99 VSSO N5 L=6e-07 W=1.5e-05 rf_flag=0
M9 96 7 VSSO VSSO N5 L=6e-07 W=1e-05 rf_flag=0
M10 VSSO 7 96 VSSO N5 L=6e-07 W=1e-05 rf_flag=0
M11 96 7 VSSO VSSO N5 L=6e-07 W=1e-05 rf_flag=0
M12 VSSO 7 96 VSSO N5 L=6e-07 W=1e-05 rf_flag=0
M13 92 12 9 VSSO N5 L=6e-07 W=1e-05 rf_flag=0
M14 9 12 92 VSSO N5 L=6e-07 W=1e-05 rf_flag=0
M15 9 12 91 VSSO N5 L=8e-06 W=1.5e-06 rf_flag=0
M16 VSSO 14 91 VSSO N5 L=8e-06 W=1.5e-06 rf_flag=0
M17 92 13 VSSO VSSO N5 L=6e-07 W=1e-05 rf_flag=0
M18 VSSO 13 92 VSSO N5 L=6e-07 W=1e-05 rf_flag=0
M19 120 7 VSSO VSSO N5 L=6e-07 W=5e-06 rf_flag=0
M20 121 15 120 VSSO N5 L=6e-07 W=5e-06 rf_flag=0
M21 22 10 121 VSSO N5 L=6e-07 W=5e-06 rf_flag=0
M22 122 19 VSSO VSSO N5 L=6e-07 W=4e-05 rf_flag=0
M23 PAD 34 122 VSSO N5 L=6e-07 W=4e-05 rf_flag=0
M24 123 34 PAD VSSO N5 L=6e-07 W=4e-05 rf_flag=0
M25 VSSO 16 123 VSSO N5 L=6e-07 W=4e-05 rf_flag=0
M26 124 19 VSSO VSSO N5 L=6e-07 W=4e-05 rf_flag=0
M27 PAD 34 124 VSSO N5 L=6e-07 W=4e-05 rf_flag=0
M28 125 34 PAD VSSO N5 L=6e-07 W=4e-05 rf_flag=0
M29 VSSO 16 125 VSSO N5 L=6e-07 W=4e-05 rf_flag=0
M30 126 19 VSSO VSSO N5 L=6e-07 W=4e-05 rf_flag=0
M31 PAD 34 126 VSSO N5 L=6e-07 W=4e-05 rf_flag=0
M32 127 34 PAD VSSO N5 L=6e-07 W=4e-05 rf_flag=0
M33 VSSO 16 127 VSSO N5 L=6e-07 W=4e-05 rf_flag=0
M34 128 19 VSSO VSSO N5 L=6e-07 W=4e-05 rf_flag=0
M35 PAD 34 128 VSSO N5 L=6e-07 W=4e-05 rf_flag=0
M36 129 34 PAD VSSO N5 L=6e-07 W=4e-05 rf_flag=0
M37 VSSO 17 129 VSSO N5 L=6e-07 W=4e-05 rf_flag=0
M38 130 19 VSSO VSSO N5 L=6e-07 W=4e-05 rf_flag=0
M39 PAD 34 130 VSSO N5 L=6e-07 W=4e-05 rf_flag=0
M40 131 34 PAD VSSO N5 L=6e-07 W=4e-05 rf_flag=0
M41 VSSO 17 131 VSSO N5 L=6e-07 W=4e-05 rf_flag=0
M42 132 19 VSSO VSSO N5 L=6e-07 W=4e-05 rf_flag=0
M43 PAD 34 132 VSSO N5 L=6e-07 W=4e-05 rf_flag=0
M44 133 34 PAD VSSO N5 L=6e-07 W=4e-05 rf_flag=0
M45 VSSO 17 133 VSSO N5 L=6e-07 W=4e-05 rf_flag=0
M46 134 19 VSSO VSSO N5 L=6e-07 W=4e-05 rf_flag=0
M47 PAD 34 134 VSSO N5 L=6e-07 W=4e-05 rf_flag=0
M48 135 34 PAD VSSO N5 L=6e-07 W=4e-05 rf_flag=0
M49 VSSO 18 135 VSSO N5 L=6e-07 W=4e-05 rf_flag=0
M50 136 19 VSSO VSSO N5 L=6e-07 W=4e-05 rf_flag=0
M51 PAD 34 136 VSSO N5 L=6e-07 W=4e-05 rf_flag=0
M52 137 34 PAD VSSO N5 L=6e-07 W=4e-05 rf_flag=0
M53 VSSO 18 137 VSSO N5 L=6e-07 W=4e-05 rf_flag=0
M54 84 34 97 VSSO N5 L=6e-07 W=1.5e-05 rf_flag=0
M55 21 24 VSSO VSSO N5 L=6e-07 W=7.5e-06 rf_flag=0
M56 VSSO 25 24 VSSO N5 L=6e-07 W=7.5e-06 rf_flag=0
M57 21 27 VSSO VSSO N5 L=6e-07 W=5e-06 rf_flag=0
M58 VSSO 27 21 VSSO N5 L=6e-07 W=5e-06 rf_flag=0
M59 30 IE VSSO VSSO N5 L=6e-07 W=6.5e-06 rf_flag=0
M60 VSSO IE 30 VSSO N5 L=6e-07 W=6.5e-06 rf_flag=0
M61 7 6 VSSO VSSO N5 L=6e-07 W=3.75e-06 rf_flag=0
M62 VSSO 6 7 VSSO N5 L=6e-07 W=3.75e-06 rf_flag=0
M63 6 21 VSSO VSSO N5 L=6e-07 W=3.75e-06 rf_flag=0
M64 VSSO 21 6 VSSO N5 L=6e-07 W=3.75e-06 rf_flag=0
M65 VSSO 26 19 VSSO N5 L=3e-06 W=5e-06 rf_flag=0
M66 VSSO 33 104 VSSO N5 L=6e-07 W=1e-05 rf_flag=0
M67 104 33 VSSO VSSO N5 L=6e-07 W=1e-05 rf_flag=0
M68 VSSO SCHM_ON 59 VSSO N5 L=6e-07 W=6.5e-06 rf_flag=0
M69 59 SCHM_ON VSSO VSSO N5 L=6e-07 W=6.5e-06 rf_flag=0
M70 35 EN VSSO VSSO N5 L=6e-07 W=9e-06 rf_flag=0
M71 VSSO 31 40 VSSO N5 L=6e-07 W=7.5e-06 rf_flag=0
M72 40 31 VSSO VSSO N5 L=6e-07 W=7.5e-06 rf_flag=0
M73 65 34 62 VSSO N5 L=6e-07 W=1.5e-05 rf_flag=0
M74 99 34 83 VSSO N5 L=6e-07 W=1.5e-05 rf_flag=0
M75 83 34 99 VSSO N5 L=6e-07 W=1.5e-05 rf_flag=0
M76 VSSO 38 31 VSSO N5 L=6e-07 W=3e-06 rf_flag=0
M77 38 25 VSSO VSSO N5 L=6e-07 W=3e-06 rf_flag=0
M78 100 36 VSSO VSSO N5 L=6e-07 W=6.67e-06 rf_flag=0
M79 VSSO 36 100 VSSO N5 L=6e-07 W=6.67e-06 rf_flag=0
M80 101 36 VSSO VSSO N5 L=6e-07 W=6.67e-06 rf_flag=0
M81 31 25 101 VSSO N5 L=6e-07 W=6.67e-06 rf_flag=0
M82 100 25 31 VSSO N5 L=6e-07 W=6.67e-06 rf_flag=0
M83 31 25 100 VSSO N5 L=6e-07 W=6.67e-06 rf_flag=0
M84 VSSO 39 47 VSSO N5 L=6e-07 W=7.5e-06 rf_flag=0
M85 47 39 VSSO VSSO N5 L=6e-07 W=7.5e-06 rf_flag=0
M86 44 25 104 VSSO N5 L=6e-07 W=1e-05 rf_flag=0
M87 104 25 44 VSSO N5 L=6e-07 W=1e-05 rf_flag=0
M88 106 42 VSSO VSSO N5 L=6e-07 W=6.67e-06 rf_flag=0
M89 VSSO 42 106 VSSO N5 L=6e-07 W=6.67e-06 rf_flag=0
M90 106 42 VSSO VSSO N5 L=6e-07 W=6.67e-06 rf_flag=0
M91 39 25 106 VSSO N5 L=6e-07 W=5e-06 rf_flag=0
M92 106 25 39 VSSO N5 L=6e-07 W=5e-06 rf_flag=0
M93 39 25 106 VSSO N5 L=6e-07 W=5e-06 rf_flag=0
M94 106 25 39 VSSO N5 L=6e-07 W=5e-06 rf_flag=0
M95 VSSO I 41 VSSO N5 L=6e-07 W=9e-06 rf_flag=0
M96 48 15 VSSO VSSO N5 L=6e-07 W=5e-06 rf_flag=0
M97 49 44 VSSO VSSO N5 L=6e-07 W=7.5e-06 rf_flag=0
M98 VSSO 46 11 VSSO N5 L=6e-07 W=5e-06 rf_flag=0
M99 11 46 VSSO VSSO N5 L=6e-07 W=5e-06 rf_flag=0
M100 VSSO 46 11 VSSO N5 L=6e-07 W=5e-06 rf_flag=0
M101 11 47 VSSO VSSO N5 L=6e-07 W=5e-06 rf_flag=0
M102 VSSO 47 11 VSSO N5 L=6e-07 W=5e-06 rf_flag=0
M103 11 47 VSSO VSSO N5 L=6e-07 W=5e-06 rf_flag=0
M104 VSSO 40 11 VSSO N5 L=6e-07 W=5e-06 rf_flag=0
M105 11 40 VSSO VSSO N5 L=6e-07 W=5e-06 rf_flag=0
M106 VSSO 40 11 VSSO N5 L=6e-07 W=5e-06 rf_flag=0
M107 54 18 VSSO VSSO N5 L=6e-07 W=5e-06 rf_flag=0
M108 VSSO 54 46 VSSO N5 L=6e-07 W=5e-06 rf_flag=0
M109 46 54 VSSO VSSO N5 L=6e-07 W=5e-06 rf_flag=0
M110 VSSO 53 18 VSSO N5 L=6e-07 W=7.5e-06 rf_flag=0
M111 18 53 VSSO VSSO N5 L=6e-07 W=7.5e-06 rf_flag=0
M112 VSSO 53 17 VSSO N5 L=6e-07 W=7.5e-06 rf_flag=0
M113 17 53 VSSO VSSO N5 L=6e-07 W=7.5e-06 rf_flag=0
M114 108 48 VSSO VSSO N5 L=6e-07 W=1.75e-06 rf_flag=0
M115 15 55 108 VSSO N5 L=6e-07 W=3.5e-06 rf_flag=0
M116 VSSO 49 55 VSSO N5 L=6e-07 W=5e-06 rf_flag=0
M117 16 52 VSSO VSSO N5 L=6e-07 W=1e-05 rf_flag=0
M118 VSSO 52 16 VSSO N5 L=6e-07 W=1e-05 rf_flag=0
M119 16 52 VSSO VSSO N5 L=6e-07 W=1e-05 rf_flag=0
M120 15 TTL_ON 112 VSSO N5 L=6e-07 W=6.25e-06 rf_flag=0
M121 112 TTL_ON 15 VSSO N5 L=6e-07 W=6.25e-06 rf_flag=0
M122 15 TTL_ON 112 VSSO N5 L=6e-07 W=6.25e-06 rf_flag=0
M123 112 TTL_ON 15 VSSO N5 L=6e-07 W=6.25e-06 rf_flag=0
M124 78 56 VSSO VSSO N5 L=6e-07 W=5e-06 rf_flag=0
M125 VSSO 56 78 VSSO N5 L=6e-07 W=5e-06 rf_flag=0
M126 56 62 VSSO VSSO N5 L=6e-07 W=5e-06 rf_flag=0
M127 110 60 58 VSS N5 L=6e-07 W=3.5e-06 rf_flag=0
M128 58 60 110 VSS N5 L=6e-07 W=3.5e-06 rf_flag=0
M129 110 60 58 VSS N5 L=6e-07 W=3.5e-06 rf_flag=0
M130 VSSO 61 28 VSSO N5 L=6e-07 W=1e-05 rf_flag=0
M131 28 61 VSSO VSSO N5 L=6e-07 W=1e-05 rf_flag=0
M132 58 60 110 VSS N5 L=6e-07 W=3.5e-06 rf_flag=0
M133 15 8 96 VSSO N5 L=6e-07 W=7.5e-06 rf_flag=0
M134 110 60 58 VSS N5 L=6e-07 W=3.5e-06 rf_flag=0
M135 96 8 112 VSSO N5 L=6e-07 W=6.25e-06 rf_flag=0
M136 112 8 96 VSSO N5 L=6e-07 W=6.25e-06 rf_flag=0
M137 96 8 112 VSSO N5 L=6e-07 W=6.25e-06 rf_flag=0
M138 112 8 96 VSSO N5 L=6e-07 W=6.25e-06 rf_flag=0
M139 58 60 110 VSS N5 L=6e-07 W=3.5e-06 rf_flag=0
M140 61 66 113 VSSO N5 L=6e-07 W=5e-06 rf_flag=0
M141 113 66 61 VSSO N5 L=6e-07 W=5e-06 rf_flag=0
M142 VSSO 11 113 VSSO N5 L=6e-07 W=5e-06 rf_flag=0
M143 113 11 VSSO VSSO N5 L=6e-07 W=5e-06 rf_flag=0
M144 110 60 58 VSS N5 L=6e-07 W=3.5e-06 rf_flag=0
M145 58 60 110 VSS N5 L=6e-07 W=3.5e-06 rf_flag=0
M146 110 60 58 VSS N5 L=6e-07 W=3.5e-06 rf_flag=0
M147 58 60 110 VSS N5 L=6e-07 W=3.5e-06 rf_flag=0
M148 63 15 VSS VSS N5 L=6e-07 W=4.5e-06 rf_flag=0
M149 VSS 15 63 VSS N5 L=6e-07 W=4.5e-06 rf_flag=0
M150 82 15 VSSO VSSO N5 L=6e-07 W=5e-06 rf_flag=0
M151 VSSO 15 82 VSSO N5 L=6e-07 W=5e-06 rf_flag=0
M152 74 70 VSSO VSSO N5 L=6e-07 W=5e-06 rf_flag=0
M153 VSSO 71 114 VSSO N5 L=6e-07 W=7.5e-06 rf_flag=0
M154 114 71 VSSO VSSO N5 L=6e-07 W=7.5e-06 rf_flag=0
M155 116 47 114 VSSO N5 L=6e-07 W=7.5e-06 rf_flag=0
M156 114 47 116 VSSO N5 L=6e-07 W=7.5e-06 rf_flag=0
M157 53 78 116 VSSO N5 L=6e-07 W=7.5e-06 rf_flag=0
M158 116 78 53 VSSO N5 L=6e-07 W=7.5e-06 rf_flag=0
M159 9 40 64 VSSO N5 L=6e-07 W=6e-06 rf_flag=0
M160 72 73 VSSO VSSO N5 L=6e-07 W=6.67e-06 rf_flag=0
M161 VSSO 73 72 VSSO N5 L=6e-07 W=6.67e-06 rf_flag=0
M162 72 73 VSSO VSSO N5 L=6e-07 W=6.67e-06 rf_flag=0
M163 VSS 82 110 VSS N5 L=6e-07 W=3.5e-06 rf_flag=0
M164 110 82 VSS VSS N5 L=6e-07 W=3.5e-06 rf_flag=0
M165 VSS 82 110 VSS N5 L=6e-07 W=3.5e-06 rf_flag=0
M166 110 82 VSS VSS N5 L=6e-07 W=3.5e-06 rf_flag=0
M167 VSS 82 110 VSS N5 L=6e-07 W=3.5e-06 rf_flag=0
M168 110 82 VSS VSS N5 L=6e-07 W=3.5e-06 rf_flag=0
M169 75 79 VSSO VSSO N5 L=6e-07 W=9e-06 rf_flag=0
M170 VSS 82 110 VSS N5 L=6e-07 W=3.5e-06 rf_flag=0
M171 VSSO 80 81 VSSO N5 L=6e-07 W=1e-05 rf_flag=0
M172 81 53 VSSO VSSO N5 L=6e-07 W=1e-05 rf_flag=0
M173 64 77 118 VSSO N5 L=6e-07 W=1e-05 rf_flag=0
M174 118 77 64 VSSO N5 L=6e-07 W=1e-05 rf_flag=0
M175 64 77 118 VSSO N5 L=6e-07 W=1e-05 rf_flag=0
M176 VSSO 80 66 VSSO N5 L=6e-07 W=7.5e-06 rf_flag=0
M177 66 80 VSSO VSSO N5 L=6e-07 W=7.5e-06 rf_flag=0
M178 VSSO 72 70 VSSO N5 L=6e-07 W=7.5e-06 rf_flag=0
M179 70 72 VSSO VSSO N5 L=6e-07 W=7.5e-06 rf_flag=0
M180 110 82 VSS VSS N5 L=6e-07 W=3.5e-06 rf_flag=0
M181 VSSO 81 52 VSSO N5 L=6e-07 W=7.5e-06 rf_flag=0
M182 52 81 VSSO VSSO N5 L=6e-07 W=7.5e-06 rf_flag=0
M183 VSS 82 110 VSS N5 L=6e-07 W=3.5e-06 rf_flag=0
M184 VSSO 40 71 VSSO N5 L=6e-07 W=7.5e-06 rf_flag=0
M185 71 40 VSSO VSSO N5 L=6e-07 W=7.5e-06 rf_flag=0
M186 110 82 VSS VSS N5 L=6e-07 W=3.5e-06 rf_flag=0
M187 118 71 VSSO VSSO N5 L=6e-07 W=5e-06 rf_flag=0
M188 119 85 VSSO VSSO N5 L=6e-07 W=6.67e-06 rf_flag=0
M189 VSSO 85 119 VSSO N5 L=6e-07 W=6.67e-06 rf_flag=0
M190 119 85 VSSO VSSO N5 L=6e-07 W=6.67e-06 rf_flag=0
M191 80 86 VSSO VSSO N5 L=6e-07 W=5e-06 rf_flag=0
M192 VSSO 86 80 VSSO N5 L=6e-07 W=5e-06 rf_flag=0
M193 80 86 VSSO VSSO N5 L=6e-07 W=5e-06 rf_flag=0
M194 119 25 86 VSSO N5 L=6e-07 W=4e-06 rf_flag=0
M195 86 25 119 VSSO N5 L=6e-07 W=4e-06 rf_flag=0
M196 119 25 86 VSSO N5 L=6e-07 W=4e-06 rf_flag=0
M197 86 25 119 VSSO N5 L=6e-07 W=4e-06 rf_flag=0
M198 119 25 86 VSSO N5 L=6e-07 W=4e-06 rf_flag=0
M199 89 DRIVE_STR VSSO VSSO N5 L=6e-07 W=3e-06 rf_flag=0
M200 VSSO DRIVE_STR 89 VSSO N5 L=6e-07 W=3e-06 rf_flag=0
M201 89 DRIVE_STR VSSO VSSO N5 L=6e-07 W=3e-06 rf_flag=0
M202 27 IE VSS VSS N L=1.8e-07 W=2.5e-06 rf_flag=0
M203 VSS IE 27 VSS N L=1.8e-07 W=2.5e-06 rf_flag=0
M204 VSS SCHM_ON 33 VSS N L=1.8e-07 W=2.5e-06 rf_flag=0
M205 33 SCHM_ON VSS VSS N L=1.8e-07 W=2.5e-06 rf_flag=0
M206 VSS EN 36 VSS N L=1.8e-07 W=2.5e-06 rf_flag=0
M207 36 EN VSS VSS N L=1.8e-07 W=2.5e-06 rf_flag=0
M208 VSS EN 36 VSS N L=1.8e-07 W=2.5e-06 rf_flag=0
M209 36 EN VSS VSS N L=1.8e-07 W=2.5e-06 rf_flag=0
M210 VSS I 42 VSS N L=1.8e-07 W=2.5e-06 rf_flag=0
M211 42 I VSS VSS N L=1.8e-07 W=2.5e-06 rf_flag=0
M212 VSS I 42 VSS N L=1.8e-07 W=2.5e-06 rf_flag=0
M213 42 I VSS VSS N L=1.8e-07 W=2.5e-06 rf_flag=0
M214 VSS PULL_UP_DOWN 14 VSS N L=1.8e-07 W=2.5e-06 rf_flag=0
M215 14 PULL_UP_DOWN VSS VSS N L=1.8e-07 W=2.5e-06 rf_flag=0
M216 VSS PULL_UP_DOWN 14 VSS N L=1.8e-07 W=2.5e-06 rf_flag=0
M217 14 PULL_UP_DOWN VSS VSS N L=1.8e-07 W=2.5e-06 rf_flag=0
M218 VSS PULL_UP_DOWN 14 VSS N L=1.8e-07 W=2.5e-06 rf_flag=0
M219 14 PULL_UP_DOWN VSS VSS N L=1.8e-07 W=2.5e-06 rf_flag=0
M220 VSS 45 14 VSS N L=1.8e-07 W=2.5e-06 rf_flag=0
M221 14 45 VSS VSS N L=1.8e-07 W=2.5e-06 rf_flag=0
M222 VSS 45 14 VSS N L=1.8e-07 W=2.5e-06 rf_flag=0
M223 14 45 VSS VSS N L=1.8e-07 W=2.5e-06 rf_flag=0
M224 VSS 45 14 VSS N L=1.8e-07 W=2.5e-06 rf_flag=0
M225 14 45 VSS VSS N L=1.8e-07 W=2.5e-06 rf_flag=0
M226 45 PULL_ON VSS VSS N L=1.8e-07 W=3.5e-06 rf_flag=0
M227 VSS PULL_ON 45 VSS N L=1.8e-07 W=3.5e-06 rf_flag=0
M228 VSS PULL_ON 107 VSS N L=1.8e-07 W=3.5e-06 rf_flag=0
M229 107 PULL_ON VSS VSS N L=1.8e-07 W=3.5e-06 rf_flag=0
M230 79 PULL_UP_DOWN 107 VSS N L=1.8e-07 W=3.5e-06 rf_flag=0
M231 107 PULL_UP_DOWN 79 VSS N L=1.8e-07 W=3.5e-06 rf_flag=0
M232 CIN 58 VSS VSS N L=1.8e-07 W=3.75e-06 rf_flag=0
M233 VSS 58 CIN VSS N L=1.8e-07 W=3.75e-06 rf_flag=0
M234 CIN 58 VSS VSS N L=1.8e-07 W=3.75e-06 rf_flag=0
M235 VSS 58 CIN VSS N L=1.8e-07 W=3.75e-06 rf_flag=0
M236 73 79 VSS VSS N L=1.8e-07 W=5e-06 rf_flag=0
M237 VSS 79 73 VSS N L=1.8e-07 W=5e-06 rf_flag=0
M238 85 DRIVE_STR VSS VSS N L=1.8e-07 W=5e-06 rf_flag=0
M239 VSS DRIVE_STR 85 VSS N L=1.8e-07 W=5e-06 rf_flag=0
M240 VDDO 6 7 VDDO P5 L=5e-07 W=1e-05 rf_flag=0
M241 6 21 VDDO VDDO P5 L=5e-07 W=1e-05 rf_flag=0
M242 94 6 VDDO VDDO P5 L=5e-07 W=1e-05 rf_flag=0
M243 VDDO 6 94 VDDO P5 L=5e-07 W=1e-05 rf_flag=0
M244 15 7 VDDO VDDO P5 L=5e-07 W=1e-05 rf_flag=0
M245 VDDO 7 15 VDDO P5 L=5e-07 W=1e-05 rf_flag=0
M246 15 8 95 VDDO P5 L=5e-07 W=1e-05 rf_flag=0
M247 95 8 15 VDDO P5 L=5e-07 W=1e-05 rf_flag=0
M248 95 6 93 VDDO P5 L=5e-07 W=1e-05 rf_flag=0
M249 93 6 95 VDDO P5 L=5e-07 W=1e-05 rf_flag=0
M250 95 6 93 VDDO P5 L=5e-07 W=1e-05 rf_flag=0
M251 93 6 95 VDDO P5 L=5e-07 W=1e-05 rf_flag=0
M252 93 9 VDDO VDDO P5 L=5e-07 W=1e-05 rf_flag=0
M253 VDDO 9 93 VDDO P5 L=5e-07 W=1e-05 rf_flag=0
M254 98 30 21 VDDO P5 L=5e-07 W=5e-06 rf_flag=0
M255 24 25 VDDO VDDO P5 L=5e-07 W=5e-06 rf_flag=0
M256 VDDO 25 24 VDDO P5 L=5e-07 W=5e-06 rf_flag=0
M257 98 24 VDDO VDDO P5 L=5e-07 W=5e-06 rf_flag=0
M258 VDDO 24 98 VDDO P5 L=5e-07 W=5e-06 rf_flag=0
M259 98 24 VDDO VDDO P5 L=5e-07 W=5e-06 rf_flag=0
M260 VDDO 21 30 VDDO P5 L=5e-07 W=2e-06 rf_flag=0
M261 VDDO 11 62 VDDO P5 L=5e-07 W=6e-06 rf_flag=0
M262 97 11 VDDO VDDO P5 L=5e-07 W=1e-05 rf_flag=0
M263 VDDO 28 99 VDDO P5 L=5e-07 W=1e-05 rf_flag=0
M264 99 28 VDDO VDDO P5 L=5e-07 W=1e-05 rf_flag=0
M265 40 31 VDDO VDDO P5 L=5e-07 W=6.67e-06 rf_flag=0
M266 VDDO 31 40 VDDO P5 L=5e-07 W=6.67e-06 rf_flag=0
M267 40 31 VDDO VDDO P5 L=5e-07 W=6.67e-06 rf_flag=0
M268 VDDO 25 38 VDDO P5 L=5e-07 W=5e-06 rf_flag=0
M269 VDDO 35 31 VDDO P5 L=5e-07 W=5e-06 rf_flag=0
M270 VDDO 31 35 VDDO P5 L=5e-07 W=2e-06 rf_flag=0
M271 VDDO 39 41 VDDO P5 L=5e-07 W=2e-06 rf_flag=0
M272 102 40 11 VDDO P5 L=5e-07 W=1.5e-05 rf_flag=0
M273 103 47 102 VDDO P5 L=5e-07 W=1.5e-05 rf_flag=0
M274 VDDO 46 103 VDDO P5 L=5e-07 W=1.5e-05 rf_flag=0
M275 39 25 VDDO VDDO P5 L=5e-07 W=5e-06 rf_flag=0
M276 VDDO 25 44 VDDO P5 L=5e-07 W=5e-06 rf_flag=0
M277 39 41 VDDO VDDO P5 L=5e-07 W=5e-06 rf_flag=0
M278 VDDO 39 47 VDDO P5 L=5e-07 W=1e-05 rf_flag=0
M279 47 39 VDDO VDDO P5 L=5e-07 W=1e-05 rf_flag=0
M280 VDDO 49 55 VDDO P5 L=5e-07 W=6e-06 rf_flag=0
M281 49 44 VDDO VDDO P5 L=5e-07 W=5e-06 rf_flag=0
M282 VDDO 44 49 VDDO P5 L=5e-07 W=5e-06 rf_flag=0
M283 111 48 VDDO VDDO P5 L=5e-07 W=4.5e-06 rf_flag=0
M284 17 52 16 VDDO P5 L=5e-07 W=1e-05 rf_flag=0
M285 16 52 17 VDDO P5 L=5e-07 W=1e-05 rf_flag=0
M286 17 52 16 VDDO P5 L=5e-07 W=1e-05 rf_flag=0
M287 18 53 17 VDDO P5 L=5e-07 W=1e-05 rf_flag=0
M288 17 53 18 VDDO P5 L=5e-07 W=1e-05 rf_flag=0
M289 18 53 17 VDDO P5 L=5e-07 W=1e-05 rf_flag=0
M290 VDDO 53 18 VDDO P5 L=5e-07 W=1e-05 rf_flag=0
M291 18 53 VDDO VDDO P5 L=5e-07 W=1e-05 rf_flag=0
M292 VDDO 53 18 VDDO P5 L=5e-07 W=1e-05 rf_flag=0
M293 54 18 VDDO VDDO P5 L=5e-07 W=7.5e-06 rf_flag=0
M294 VDDO 54 46 VDDO P5 L=5e-07 W=7.5e-06 rf_flag=0
M295 46 54 VDDO VDDO P5 L=5e-07 W=7.5e-06 rf_flag=0
M296 VDDO 59 44 VDDO P5 L=5e-07 W=5e-06 rf_flag=0
M297 VDDO 62 56 VDDO P5 L=5e-07 W=7.5e-06 rf_flag=0
M298 78 56 VDDO VDDO P5 L=5e-07 W=7.5e-06 rf_flag=0
M299 VDDO 56 78 VDDO P5 L=5e-07 W=7.5e-06 rf_flag=0
M300 59 44 VDDO VDDO P5 L=5e-07 W=2e-06 rf_flag=0
M301 48 15 VDDO VDDO P5 L=5e-07 W=1e-05 rf_flag=0
M302 15 49 111 VDDO P5 L=5e-07 W=9e-06 rf_flag=0
M303 VDDO 15 82 VDDO P5 L=5e-07 W=5e-06 rf_flag=0
M304 82 15 VDDO VDDO P5 L=5e-07 W=5e-06 rf_flag=0
M305 97 64 84 VMAX P5 L=5e-07 W=1e-05 rf_flag=0
M306 84 64 97 VMAX P5 L=5e-07 W=1e-05 rf_flag=0
M307 VMAX 67 83 VMAX P5 L=5e-07 W=1e-05 rf_flag=0
M308 PAD 83 VDDO VMAX P5 L=5e-07 W=2.08e-05 rf_flag=0
M309 VDDO 83 PAD VMAX P5 L=5e-07 W=2.08e-05 rf_flag=0
M310 PAD 83 VDDO VMAX P5 L=5e-07 W=2.08e-05 rf_flag=0
M311 VDDO 83 PAD VMAX P5 L=5e-07 W=2.08e-05 rf_flag=0
M312 PAD 83 VDDO VMAX P5 L=5e-07 W=2.08e-05 rf_flag=0
M313 VDDO 83 PAD VMAX P5 L=5e-07 W=2.08e-05 rf_flag=0
M314 PAD 83 VDDO VMAX P5 L=5e-07 W=2.08e-05 rf_flag=0
M315 VDDO 83 PAD VMAX P5 L=5e-07 W=2.08e-05 rf_flag=0
M316 PAD 83 VDDO VMAX P5 L=5e-07 W=2.08e-05 rf_flag=0
M317 VDDO 83 PAD VMAX P5 L=5e-07 W=2.08e-05 rf_flag=0
M318 PAD 84 VDDO VMAX P5 L=5e-07 W=2.08e-05 rf_flag=0
M319 VDDO 84 PAD VMAX P5 L=5e-07 W=2.08e-05 rf_flag=0
M320 PAD 84 VDDO VMAX P5 L=5e-07 W=2.08e-05 rf_flag=0
M321 VDDO 84 PAD VMAX P5 L=5e-07 W=2.08e-05 rf_flag=0
M322 PAD 84 VDDO VMAX P5 L=5e-07 W=2.08e-05 rf_flag=0
M323 VDDO 84 PAD VMAX P5 L=5e-07 W=2.08e-05 rf_flag=0
M324 PAD 65 VDDO VMAX P5 L=5e-07 W=2.08e-05 rf_flag=0
M325 VDDO 65 PAD VMAX P5 L=5e-07 W=2.08e-05 rf_flag=0
M326 PAD 65 VDDO VMAX P5 L=5e-07 W=2.08e-05 rf_flag=0
M327 VDDO 65 PAD VMAX P5 L=5e-07 W=2.08e-05 rf_flag=0
M328 VDDO 61 28 VDDO P5 L=5e-07 W=7.5e-06 rf_flag=0
M329 28 61 VDDO VDDO P5 L=5e-07 W=7.5e-06 rf_flag=0
M330 61 66 VDDO VDDO P5 L=5e-07 W=7.5e-06 rf_flag=0
M331 VDDO 11 61 VDDO P5 L=5e-07 W=7.5e-06 rf_flag=0
M332 99 64 83 VMAX P5 L=5e-07 W=1e-05 rf_flag=0
M333 83 64 99 VMAX P5 L=5e-07 W=1e-05 rf_flag=0
M334 99 64 83 VMAX P5 L=5e-07 W=1e-05 rf_flag=0
M335 62 64 65 VMAX P5 L=5e-07 W=1e-05 rf_flag=0
M336 65 64 62 VMAX P5 L=5e-07 W=1e-05 rf_flag=0
M337 9 67 64 VMAX P5 L=5e-07 W=5e-06 rf_flag=0
M338 64 67 9 VMAX P5 L=5e-07 W=5e-06 rf_flag=0
M339 9 67 64 VMAX P5 L=5e-07 W=5e-06 rf_flag=0
M340 64 67 9 VMAX P5 L=5e-07 W=5e-06 rf_flag=0
M341 VMAX 67 84 VMAX P5 L=5e-07 W=5e-06 rf_flag=0
M342 65 67 VMAX VMAX P5 L=5e-07 W=5e-06 rf_flag=0
M343 53 71 VDDO VDDO P5 L=5e-07 W=1.5e-05 rf_flag=0
M344 VDDO 47 53 VDDO P5 L=5e-07 W=1.5e-05 rf_flag=0
M345 53 78 VDDO VDDO P5 L=5e-07 W=1.5e-05 rf_flag=0
M346 VDDO 64 115 VMAX P5 L=6e-07 W=5e-06 rf_flag=0
M347 VDDO 72 70 VDDO P5 L=5e-07 W=1e-05 rf_flag=0
M348 70 72 VDDO VDDO P5 L=5e-07 W=1e-05 rf_flag=0
M349 72 75 VDDO VDDO P5 L=5e-07 W=5e-06 rf_flag=0
M350 VDDO 72 75 VDDO P5 L=5e-07 W=2e-06 rf_flag=0
M351 74 70 VDDO VDDO P5 L=5e-07 W=7e-06 rf_flag=0
M352 115 74 9 VMAX P5 L=4e-06 W=2.5e-06 rf_flag=0
M353 VMAX VMAX VDDO VMAX P5 L=5e-07 W=1.5e-05 rf_flag=0
M354 VDDO VMAX VMAX VMAX P5 L=5e-07 W=1.5e-05 rf_flag=0
M355 VMAX VMAX VDDO VMAX P5 L=5e-07 W=1.5e-05 rf_flag=0
M356 VDDO VMAX VMAX VMAX P5 L=5e-07 W=1.5e-05 rf_flag=0
M357 VMAX 9 VDDO VMAX P5 L=5e-07 W=1.5e-05 rf_flag=0
M358 9 67 VMAX VMAX P5 L=5e-07 W=1.5e-05 rf_flag=0
M359 VDDO 64 VMAX VMAX P5 L=5e-07 W=1.5e-05 rf_flag=0
M360 VMAX 64 VDDO VMAX P5 L=5e-07 W=1.5e-05 rf_flag=0
M361 VDDO 64 VMAX VMAX P5 L=5e-07 W=1.5e-05 rf_flag=0
M362 VMAX 64 VDDO VMAX P5 L=5e-07 W=1.5e-05 rf_flag=0
M363 VDDO 64 VMAX VMAX P5 L=5e-07 W=1.5e-05 rf_flag=0
M364 VMAX 64 VDDO VMAX P5 L=5e-07 W=1.5e-05 rf_flag=0
M365 VDDO 64 VMAX VMAX P5 L=5e-07 W=1.5e-05 rf_flag=0
M366 VMAX 64 VDDO VMAX P5 L=5e-07 W=1.5e-05 rf_flag=0
M367 8 22 9 VMAX P5 L=5e-07 W=1e-05 rf_flag=0
M368 9 22 8 VMAX P5 L=5e-07 W=1e-05 rf_flag=0
M369 22 10 9 VMAX P5 L=5e-07 W=1e-05 rf_flag=0
M370 VDDO 80 117 VDDO P5 L=5e-07 W=7.5e-06 rf_flag=0
M371 117 80 VDDO VDDO P5 L=5e-07 W=7.5e-06 rf_flag=0
M372 81 53 117 VDDO P5 L=5e-07 W=7.5e-06 rf_flag=0
M373 117 53 81 VDDO P5 L=5e-07 W=7.5e-06 rf_flag=0
M374 VDDO 80 66 VDDO P5 L=5e-07 W=6e-06 rf_flag=0
M375 66 80 VDDO VDDO P5 L=5e-07 W=6e-06 rf_flag=0
M376 VDDO 40 71 VDDO P5 L=5e-07 W=7.5e-06 rf_flag=0
M377 71 40 VDDO VDDO P5 L=5e-07 W=7.5e-06 rf_flag=0
M378 VDDO 81 52 VDDO P5 L=5e-07 W=1e-05 rf_flag=0
M379 52 81 VDDO VDDO P5 L=5e-07 W=1e-05 rf_flag=0
M380 VDDO 86 80 VDDO P5 L=5e-07 W=4e-06 rf_flag=0
M381 80 86 VDDO VDDO P5 L=5e-07 W=4e-06 rf_flag=0
M382 VDDO 86 80 VDDO P5 L=5e-07 W=4e-06 rf_flag=0
M383 80 86 VDDO VDDO P5 L=5e-07 W=4e-06 rf_flag=0
M384 VDDO 86 80 VDDO P5 L=5e-07 W=4e-06 rf_flag=0
M385 86 89 VDDO VDDO P5 L=5e-07 W=5e-06 rf_flag=0
M386 89 86 VDDO VDDO P5 L=5e-07 W=2e-06 rf_flag=0
M387 86 25 VDDO VDDO P5 L=5e-07 W=5e-06 rf_flag=0
M388 27 IE VDD VDD P L=1.8e-07 W=5e-06 rf_flag=0
M389 VDD IE 27 VDD P L=1.8e-07 W=5e-06 rf_flag=0
M390 VDD SCHM_ON 33 VDD P L=1.8e-07 W=5e-06 rf_flag=0
M391 33 SCHM_ON VDD VDD P L=1.8e-07 W=5e-06 rf_flag=0
M392 VDD EN 36 VDD P L=1.8e-07 W=5e-06 rf_flag=0
M393 36 EN VDD VDD P L=1.8e-07 W=5e-06 rf_flag=0
M394 VDD I 42 VDD P L=1.8e-07 W=5e-06 rf_flag=0
M395 42 I VDD VDD P L=1.8e-07 W=5e-06 rf_flag=0
M396 14 PULL_UP_DOWN 105 VDD P L=1.8e-07 W=4e-06 rf_flag=0
M397 105 PULL_UP_DOWN 14 VDD P L=1.8e-07 W=4e-06 rf_flag=0
M398 VDD 45 105 VDD P L=1.8e-07 W=4e-06 rf_flag=0
M399 105 45 VDD VDD P L=1.8e-07 W=4e-06 rf_flag=0
M400 VDD PULL_ON 45 VDD P L=1.8e-07 W=5e-06 rf_flag=0
M401 45 PULL_ON VDD VDD P L=1.8e-07 W=5e-06 rf_flag=0
M402 VDD PULL_ON 79 VDD P L=1.8e-07 W=5e-06 rf_flag=0
M403 79 PULL_ON VDD VDD P L=1.8e-07 W=5e-06 rf_flag=0
M404 VDD PULL_ON 79 VDD P L=1.8e-07 W=5e-06 rf_flag=0
M405 79 PULL_ON VDD VDD P L=1.8e-07 W=5e-06 rf_flag=0
M406 VDD PULL_UP_DOWN 79 VDD P L=1.8e-07 W=5e-06 rf_flag=0
M407 79 PULL_UP_DOWN VDD VDD P L=1.8e-07 W=5e-06 rf_flag=0
M408 VDD PULL_UP_DOWN 79 VDD P L=1.8e-07 W=5e-06 rf_flag=0
M409 79 PULL_UP_DOWN VDD VDD P L=1.8e-07 W=5e-06 rf_flag=0
M410 VDD 58 CIN VDD P L=1.8e-07 W=5e-06 rf_flag=0
M411 CIN 58 VDD VDD P L=1.8e-07 W=5e-06 rf_flag=0
M412 VDD 58 CIN VDD P L=1.8e-07 W=5e-06 rf_flag=0
M413 CIN 58 VDD VDD P L=1.8e-07 W=5e-06 rf_flag=0
M414 58 60 VDD VDD P L=1.8e-07 W=5e-06 rf_flag=0
M415 VDD 63 58 VDD P L=1e-06 W=2.5e-06 rf_flag=0
M416 63 58 VDD VDD P L=1.8e-07 W=2.5e-06 rf_flag=0
M417 VDD 58 63 VDD P L=1.8e-07 W=2.5e-06 rf_flag=0
M418 73 79 VDD VDD P L=1.8e-07 W=5e-06 rf_flag=0
M419 VDD 79 73 VDD P L=1.8e-07 W=5e-06 rf_flag=0
M420 85 DRIVE_STR VDD VDD P L=1.8e-07 W=5e-06 rf_flag=0
M421 VDD DRIVE_STR 85 VDD P L=1.8e-07 W=5e-06 rf_flag=0
R422 VSSO 13 1182.07 L=2.655e-06 W=1e-06 postlayout=1 $SUB=VSSO $[RD3]
R423 12 VDDO 1182.07 L=2.655e-06 W=1e-06 postlayout=1 $SUB=VSSO $[RD3]
R424 20 26 1372.42 L=3.25e-06 W=1e-06 postlayout=1 $SUB=VSSO $[RD3]
R425 20 VDDO 1372.42 L=3.25e-06 W=1e-06 postlayout=1 $SUB=VSSO $[RD3]
R426 34 50 1372.42 L=3.25e-06 W=1e-06 postlayout=1 $SUB=VSSO $[RD3]
R427 VDDO 50 1372.42 L=3.25e-06 W=1e-06 postlayout=1 $SUB=VSSO $[RD3]
R428 VDDO 77 2412.15 L=6.5e-06 W=1e-06 postlayout=1 $SUB=VSSO $[RD3]
R429 VDDO 10 972.524 L=2e-06 W=1e-06 postlayout=1 $SUB=VDDO $[RD3]
R430 PAD 69 307.767 L=2.9e-06 W=4e-06 postlayout=1 $SUB=VMAX $[RD3]
R431 60 VDD_OK 972.524 L=2e-06 W=1e-06 postlayout=1 $SUB=VDD $[RD3]
R432 69 9 307.767 L=2.9e-06 W=4e-06 postlayout=1 $SUB=VMAX $[RD3]
R433 VDDO 67 2412.15 L=6.5e-06 W=1e-06 postlayout=1 $SUB=VMAX $[RD3]
R434 25 VDDO_OK 972.524 L=2e-06 W=1e-06 postlayout=1 $SUB=VDD $[RD3]
D435 VSS VDD dwn2psub AREA=1.37174e-09 PJ=0.00051334
D436 VSS VDDO dwn2psub AREA=3.83476e-09 PJ=0.0006715
D437 VSS VDD dwn2psub AREA=1.37174e-09 PJ=0.00051334
D438 VSSO VDDO dwn2psub AREA=7.0561e-10 PJ=0.00069394
D439 VSSO VDDO dwn2psub AREA=3.83476e-09 PJ=0.0006715
D440 VSS VDDO dwn2psub AREA=7.0561e-10 PJ=0.00069394
D441 VSS VMAX dwn2psub AREA=4.53527e-09 PJ=0.00031038
.ENDS

.SUBCKT PIOHO_50_50 PAD VSSO VDDO VSS VDD SCHM_ON EN IE I VDDO_OK PULL_UP_DOWN PULL_ON TTL_ON DRIVE_STR VDD_OK CIN
*.PININFO PAD:B VSSO:B VDDO:B VSS:B VDD:B SCHM_ON:I EN:I IE:I I:I VDDO_OK:I PULL_UP_DOWN:I PULL_ON:I TTL_ON:I DRIVE_STR:I VDD_OK:I CIN:O
M0 94 23 8 VSSO N5 L=6e-07 W=1e-05 rf_flag=0
M1 8 10 9 VSSO N5 L=6e-07 W=1.0005e-05 rf_flag=0
M2 9 10 8 VSSO N5 L=6e-07 W=1.0005e-05 rf_flag=0
M3 VSSO 11 62 VSSO N5 L=6e-07 W=1.5e-05 rf_flag=0
M4 62 11 VSSO VSSO N5 L=6e-07 W=1.5e-05 rf_flag=0
M5 97 11 62 VSSO N5 L=6e-07 W=1.5e-05 rf_flag=0
M6 62 11 97 VSSO N5 L=6e-07 W=1.5e-05 rf_flag=0
M7 99 29 97 VSSO N5 L=6e-07 W=1.5e-05 rf_flag=0
M8 97 29 99 VSSO N5 L=6e-07 W=1.5e-05 rf_flag=0
M9 96 7 VSSO VSSO N5 L=6e-07 W=1e-05 rf_flag=0
M10 VSSO 7 96 VSSO N5 L=6e-07 W=1e-05 rf_flag=0
M11 96 7 VSSO VSSO N5 L=6e-07 W=1e-05 rf_flag=0
M12 VSSO 7 96 VSSO N5 L=6e-07 W=1e-05 rf_flag=0
M13 92 12 9 VSSO N5 L=6e-07 W=1e-05 rf_flag=0
M14 9 12 92 VSSO N5 L=6e-07 W=1e-05 rf_flag=0
M15 9 12 91 VSSO N5 L=8e-06 W=1.5e-06 rf_flag=0
M16 VSSO 14 91 VSSO N5 L=8e-06 W=1.5e-06 rf_flag=0
M17 92 13 VSSO VSSO N5 L=6e-07 W=1e-05 rf_flag=0
M18 VSSO 13 92 VSSO N5 L=6e-07 W=1e-05 rf_flag=0
M19 120 7 VSSO VSSO N5 L=6e-07 W=5e-06 rf_flag=0
M20 121 15 120 VSSO N5 L=6e-07 W=5e-06 rf_flag=0
M21 23 10 121 VSSO N5 L=6e-07 W=5e-06 rf_flag=0
M22 122 19 VSSO VSSO N5 L=6e-07 W=4e-05 rf_flag=0
M23 PAD 34 122 VSSO N5 L=6e-07 W=4e-05 rf_flag=0
M24 123 34 PAD VSSO N5 L=6e-07 W=4e-05 rf_flag=0
M25 VSSO 16 123 VSSO N5 L=6e-07 W=4e-05 rf_flag=0
M26 124 19 VSSO VSSO N5 L=6e-07 W=4e-05 rf_flag=0
M27 PAD 34 124 VSSO N5 L=6e-07 W=4e-05 rf_flag=0
M28 125 34 PAD VSSO N5 L=6e-07 W=4e-05 rf_flag=0
M29 VSSO 16 125 VSSO N5 L=6e-07 W=4e-05 rf_flag=0
M30 126 19 VSSO VSSO N5 L=6e-07 W=4e-05 rf_flag=0
M31 PAD 34 126 VSSO N5 L=6e-07 W=4e-05 rf_flag=0
M32 127 34 PAD VSSO N5 L=6e-07 W=4e-05 rf_flag=0
M33 VSSO 16 127 VSSO N5 L=6e-07 W=4e-05 rf_flag=0
M34 128 19 VSSO VSSO N5 L=6e-07 W=4e-05 rf_flag=0
M35 PAD 34 128 VSSO N5 L=6e-07 W=4e-05 rf_flag=0
M36 129 34 PAD VSSO N5 L=6e-07 W=4e-05 rf_flag=0
M37 VSSO 17 129 VSSO N5 L=6e-07 W=4e-05 rf_flag=0
M38 130 19 VSSO VSSO N5 L=6e-07 W=4e-05 rf_flag=0
M39 PAD 34 130 VSSO N5 L=6e-07 W=4e-05 rf_flag=0
M40 131 34 PAD VSSO N5 L=6e-07 W=4e-05 rf_flag=0
M41 VSSO 17 131 VSSO N5 L=6e-07 W=4e-05 rf_flag=0
M42 132 19 VSSO VSSO N5 L=6e-07 W=4e-05 rf_flag=0
M43 PAD 34 132 VSSO N5 L=6e-07 W=4e-05 rf_flag=0
M44 133 34 PAD VSSO N5 L=6e-07 W=4e-05 rf_flag=0
M45 VSSO 17 133 VSSO N5 L=6e-07 W=4e-05 rf_flag=0
M46 134 19 VSSO VSSO N5 L=6e-07 W=4e-05 rf_flag=0
M47 PAD 34 134 VSSO N5 L=6e-07 W=4e-05 rf_flag=0
M48 135 34 PAD VSSO N5 L=6e-07 W=4e-05 rf_flag=0
M49 VSSO 18 135 VSSO N5 L=6e-07 W=4e-05 rf_flag=0
M50 136 19 VSSO VSSO N5 L=6e-07 W=4e-05 rf_flag=0
M51 PAD 34 136 VSSO N5 L=6e-07 W=4e-05 rf_flag=0
M52 137 34 PAD VSSO N5 L=6e-07 W=4e-05 rf_flag=0
M53 VSSO 18 137 VSSO N5 L=6e-07 W=4e-05 rf_flag=0
M54 84 34 97 VSSO N5 L=6e-07 W=1.5e-05 rf_flag=0
M55 27 IE VSS VSS N5 L=6e-07 W=2.5e-06 rf_flag=0
M56 VSS IE 27 VSS N5 L=6e-07 W=2.5e-06 rf_flag=0
M57 21 24 VSSO VSSO N5 L=6e-07 W=7.5e-06 rf_flag=0
M58 VSSO 25 24 VSSO N5 L=6e-07 W=7.5e-06 rf_flag=0
M59 21 27 VSSO VSSO N5 L=6e-07 W=5e-06 rf_flag=0
M60 VSSO 27 21 VSSO N5 L=6e-07 W=5e-06 rf_flag=0
M61 30 IE VSSO VSSO N5 L=6e-07 W=6.5e-06 rf_flag=0
M62 VSSO IE 30 VSSO N5 L=6e-07 W=6.5e-06 rf_flag=0
M63 7 6 VSSO VSSO N5 L=6e-07 W=3.75e-06 rf_flag=0
M64 VSSO 6 7 VSSO N5 L=6e-07 W=3.75e-06 rf_flag=0
M65 6 21 VSSO VSSO N5 L=6e-07 W=3.75e-06 rf_flag=0
M66 VSSO 21 6 VSSO N5 L=6e-07 W=3.75e-06 rf_flag=0
M67 VSSO 26 19 VSSO N5 L=3e-06 W=5e-06 rf_flag=0
M68 VSS SCHM_ON 33 VSS N5 L=6e-07 W=2.5e-06 rf_flag=0
M69 33 SCHM_ON VSS VSS N5 L=6e-07 W=2.5e-06 rf_flag=0
M70 VSS EN 36 VSS N5 L=6e-07 W=2.5e-06 rf_flag=0
M71 36 EN VSS VSS N5 L=6e-07 W=2.5e-06 rf_flag=0
M72 VSS EN 36 VSS N5 L=6e-07 W=2.5e-06 rf_flag=0
M73 36 EN VSS VSS N5 L=6e-07 W=2.5e-06 rf_flag=0
M74 VSSO 33 104 VSSO N5 L=6e-07 W=1e-05 rf_flag=0
M75 104 33 VSSO VSSO N5 L=6e-07 W=1e-05 rf_flag=0
M76 VSSO SCHM_ON 59 VSSO N5 L=6e-07 W=6.5e-06 rf_flag=0
M77 59 SCHM_ON VSSO VSSO N5 L=6e-07 W=6.5e-06 rf_flag=0
M78 35 EN VSSO VSSO N5 L=6e-07 W=9e-06 rf_flag=0
M79 VSS I 42 VSS N5 L=6e-07 W=2.5e-06 rf_flag=0
M80 VSSO 31 40 VSSO N5 L=6e-07 W=7.5e-06 rf_flag=0
M81 40 31 VSSO VSSO N5 L=6e-07 W=7.5e-06 rf_flag=0
M82 65 34 62 VSSO N5 L=6e-07 W=1.5e-05 rf_flag=0
M83 99 34 83 VSSO N5 L=6e-07 W=1.5e-05 rf_flag=0
M84 83 34 99 VSSO N5 L=6e-07 W=1.5e-05 rf_flag=0
M85 42 I VSS VSS N5 L=6e-07 W=2.5e-06 rf_flag=0
M86 VSSO 38 31 VSSO N5 L=6e-07 W=3e-06 rf_flag=0
M87 38 25 VSSO VSSO N5 L=6e-07 W=3e-06 rf_flag=0
M88 100 36 VSSO VSSO N5 L=6e-07 W=6.67e-06 rf_flag=0
M89 VSSO 36 100 VSSO N5 L=6e-07 W=6.67e-06 rf_flag=0
M90 101 36 VSSO VSSO N5 L=6e-07 W=6.67e-06 rf_flag=0
M91 31 25 101 VSSO N5 L=6e-07 W=6.67e-06 rf_flag=0
M92 100 25 31 VSSO N5 L=6e-07 W=6.67e-06 rf_flag=0
M93 31 25 100 VSSO N5 L=6e-07 W=6.67e-06 rf_flag=0
M94 VSS I 42 VSS N5 L=6e-07 W=2.5e-06 rf_flag=0
M95 42 I VSS VSS N5 L=6e-07 W=2.5e-06 rf_flag=0
M96 VSS PULL_UP_DOWN 14 VSS N5 L=6e-07 W=2.5e-06 rf_flag=0
M97 14 PULL_UP_DOWN VSS VSS N5 L=6e-07 W=2.5e-06 rf_flag=0
M98 VSS PULL_UP_DOWN 14 VSS N5 L=6e-07 W=2.5e-06 rf_flag=0
M99 14 PULL_UP_DOWN VSS VSS N5 L=6e-07 W=2.5e-06 rf_flag=0
M100 VSSO 39 47 VSSO N5 L=6e-07 W=7.5e-06 rf_flag=0
M101 47 39 VSSO VSSO N5 L=6e-07 W=7.5e-06 rf_flag=0
M102 VSS PULL_UP_DOWN 14 VSS N5 L=6e-07 W=2.5e-06 rf_flag=0
M103 44 25 104 VSSO N5 L=6e-07 W=1e-05 rf_flag=0
M104 104 25 44 VSSO N5 L=6e-07 W=1e-05 rf_flag=0
M105 106 42 VSSO VSSO N5 L=6e-07 W=6.67e-06 rf_flag=0
M106 VSSO 42 106 VSSO N5 L=6e-07 W=6.67e-06 rf_flag=0
M107 106 42 VSSO VSSO N5 L=6e-07 W=6.67e-06 rf_flag=0
M108 39 25 106 VSSO N5 L=6e-07 W=5e-06 rf_flag=0
M109 106 25 39 VSSO N5 L=6e-07 W=5e-06 rf_flag=0
M110 39 25 106 VSSO N5 L=6e-07 W=5e-06 rf_flag=0
M111 106 25 39 VSSO N5 L=6e-07 W=5e-06 rf_flag=0
M112 VSSO I 41 VSSO N5 L=6e-07 W=9e-06 rf_flag=0
M113 14 PULL_UP_DOWN VSS VSS N5 L=6e-07 W=2.5e-06 rf_flag=0
M114 VSS 45 14 VSS N5 L=6e-07 W=2.5e-06 rf_flag=0
M115 14 45 VSS VSS N5 L=6e-07 W=2.5e-06 rf_flag=0
M116 VSS 45 14 VSS N5 L=6e-07 W=2.5e-06 rf_flag=0
M117 48 15 VSSO VSSO N5 L=6e-07 W=5e-06 rf_flag=0
M118 49 44 VSSO VSSO N5 L=6e-07 W=7.5e-06 rf_flag=0
M119 14 45 VSS VSS N5 L=6e-07 W=2.5e-06 rf_flag=0
M120 VSS 45 14 VSS N5 L=6e-07 W=2.5e-06 rf_flag=0
M121 14 45 VSS VSS N5 L=6e-07 W=2.5e-06 rf_flag=0
M122 VSSO 46 11 VSSO N5 L=6e-07 W=5e-06 rf_flag=0
M123 11 46 VSSO VSSO N5 L=6e-07 W=5e-06 rf_flag=0
M124 VSSO 46 11 VSSO N5 L=6e-07 W=5e-06 rf_flag=0
M125 11 47 VSSO VSSO N5 L=6e-07 W=5e-06 rf_flag=0
M126 VSSO 47 11 VSSO N5 L=6e-07 W=5e-06 rf_flag=0
M127 11 47 VSSO VSSO N5 L=6e-07 W=5e-06 rf_flag=0
M128 VSSO 40 11 VSSO N5 L=6e-07 W=5e-06 rf_flag=0
M129 11 40 VSSO VSSO N5 L=6e-07 W=5e-06 rf_flag=0
M130 VSSO 40 11 VSSO N5 L=6e-07 W=5e-06 rf_flag=0
M131 45 PULL_ON VSS VSS N5 L=6e-07 W=3.5e-06 rf_flag=0
M132 VSS PULL_ON 45 VSS N5 L=6e-07 W=3.5e-06 rf_flag=0
M133 VSS PULL_ON 107 VSS N5 L=6e-07 W=3.5e-06 rf_flag=0
M134 54 18 VSSO VSSO N5 L=6e-07 W=5e-06 rf_flag=0
M135 VSSO 54 46 VSSO N5 L=6e-07 W=5e-06 rf_flag=0
M136 46 54 VSSO VSSO N5 L=6e-07 W=5e-06 rf_flag=0
M137 VSSO 53 18 VSSO N5 L=6e-07 W=7.5e-06 rf_flag=0
M138 18 53 VSSO VSSO N5 L=6e-07 W=7.5e-06 rf_flag=0
M139 VSSO 53 17 VSSO N5 L=6e-07 W=7.5e-06 rf_flag=0
M140 17 53 VSSO VSSO N5 L=6e-07 W=7.5e-06 rf_flag=0
M141 107 PULL_ON VSS VSS N5 L=6e-07 W=3.5e-06 rf_flag=0
M142 108 48 VSSO VSSO N5 L=6e-07 W=1.75e-06 rf_flag=0
M143 15 55 108 VSSO N5 L=6e-07 W=3.5e-06 rf_flag=0
M144 VSSO 49 55 VSSO N5 L=6e-07 W=5e-06 rf_flag=0
M145 79 PULL_UP_DOWN 107 VSS N5 L=6e-07 W=3.5e-06 rf_flag=0
M146 16 52 VSSO VSSO N5 L=6e-07 W=1e-05 rf_flag=0
M147 VSSO 52 16 VSSO N5 L=6e-07 W=1e-05 rf_flag=0
M148 16 52 VSSO VSSO N5 L=6e-07 W=1e-05 rf_flag=0
M149 107 PULL_UP_DOWN 79 VSS N5 L=6e-07 W=3.5e-06 rf_flag=0
M150 CIN 58 VSS VSS N5 L=6e-07 W=3.75e-06 rf_flag=0
M151 VSS 58 CIN VSS N5 L=6e-07 W=3.75e-06 rf_flag=0
M152 15 TTL_ON 112 VSSO N5 L=6e-07 W=6.25e-06 rf_flag=0
M153 112 TTL_ON 15 VSSO N5 L=6e-07 W=6.25e-06 rf_flag=0
M154 15 TTL_ON 112 VSSO N5 L=6e-07 W=6.25e-06 rf_flag=0
M155 112 TTL_ON 15 VSSO N5 L=6e-07 W=6.25e-06 rf_flag=0
M156 CIN 58 VSS VSS N5 L=6e-07 W=3.75e-06 rf_flag=0
M157 78 56 VSSO VSSO N5 L=6e-07 W=5e-06 rf_flag=0
M158 VSSO 56 78 VSSO N5 L=6e-07 W=5e-06 rf_flag=0
M159 VSS 58 CIN VSS N5 L=6e-07 W=3.75e-06 rf_flag=0
M160 56 62 VSSO VSSO N5 L=6e-07 W=5e-06 rf_flag=0
M161 110 60 58 VSS N5 L=6e-07 W=3.5e-06 rf_flag=0
M162 58 60 110 VSS N5 L=6e-07 W=3.5e-06 rf_flag=0
M163 110 60 58 VSS N5 L=6e-07 W=3.5e-06 rf_flag=0
M164 VSSO 61 29 VSSO N5 L=6e-07 W=1e-05 rf_flag=0
M165 29 61 VSSO VSSO N5 L=6e-07 W=1e-05 rf_flag=0
M166 58 60 110 VSS N5 L=6e-07 W=3.5e-06 rf_flag=0
M167 15 8 96 VSSO N5 L=6e-07 W=7.5e-06 rf_flag=0
M168 110 60 58 VSS N5 L=6e-07 W=3.5e-06 rf_flag=0
M169 96 8 112 VSSO N5 L=6e-07 W=6.25e-06 rf_flag=0
M170 112 8 96 VSSO N5 L=6e-07 W=6.25e-06 rf_flag=0
M171 96 8 112 VSSO N5 L=6e-07 W=6.25e-06 rf_flag=0
M172 112 8 96 VSSO N5 L=6e-07 W=6.25e-06 rf_flag=0
M173 58 60 110 VSS N5 L=6e-07 W=3.5e-06 rf_flag=0
M174 61 66 113 VSSO N5 L=6e-07 W=5e-06 rf_flag=0
M175 113 66 61 VSSO N5 L=6e-07 W=5e-06 rf_flag=0
M176 VSSO 11 113 VSSO N5 L=6e-07 W=5e-06 rf_flag=0
M177 113 11 VSSO VSSO N5 L=6e-07 W=5e-06 rf_flag=0
M178 110 60 58 VSS N5 L=6e-07 W=3.5e-06 rf_flag=0
M179 58 60 110 VSS N5 L=6e-07 W=3.5e-06 rf_flag=0
M180 110 60 58 VSS N5 L=6e-07 W=3.5e-06 rf_flag=0
M181 58 60 110 VSS N5 L=6e-07 W=3.5e-06 rf_flag=0
M182 63 15 VSS VSS N5 L=6e-07 W=4.5e-06 rf_flag=0
M183 VSS 15 63 VSS N5 L=6e-07 W=4.5e-06 rf_flag=0
M184 82 15 VSSO VSSO N5 L=6e-07 W=5e-06 rf_flag=0
M185 VSSO 15 82 VSSO N5 L=6e-07 W=5e-06 rf_flag=0
M186 74 70 VSSO VSSO N5 L=6e-07 W=5e-06 rf_flag=0
M187 VSSO 71 114 VSSO N5 L=6e-07 W=7.5e-06 rf_flag=0
M188 114 71 VSSO VSSO N5 L=6e-07 W=7.5e-06 rf_flag=0
M189 116 47 114 VSSO N5 L=6e-07 W=7.5e-06 rf_flag=0
M190 114 47 116 VSSO N5 L=6e-07 W=7.5e-06 rf_flag=0
M191 53 78 116 VSSO N5 L=6e-07 W=7.5e-06 rf_flag=0
M192 116 78 53 VSSO N5 L=6e-07 W=7.5e-06 rf_flag=0
M193 9 40 64 VSSO N5 L=6e-07 W=6e-06 rf_flag=0
M194 72 73 VSSO VSSO N5 L=6e-07 W=6.67e-06 rf_flag=0
M195 VSSO 73 72 VSSO N5 L=6e-07 W=6.67e-06 rf_flag=0
M196 72 73 VSSO VSSO N5 L=6e-07 W=6.67e-06 rf_flag=0
M197 VSS 82 110 VSS N5 L=6e-07 W=3.5e-06 rf_flag=0
M198 110 82 VSS VSS N5 L=6e-07 W=3.5e-06 rf_flag=0
M199 VSS 82 110 VSS N5 L=6e-07 W=3.5e-06 rf_flag=0
M200 110 82 VSS VSS N5 L=6e-07 W=3.5e-06 rf_flag=0
M201 VSS 82 110 VSS N5 L=6e-07 W=3.5e-06 rf_flag=0
M202 110 82 VSS VSS N5 L=6e-07 W=3.5e-06 rf_flag=0
M203 75 79 VSSO VSSO N5 L=6e-07 W=9e-06 rf_flag=0
M204 VSS 82 110 VSS N5 L=6e-07 W=3.5e-06 rf_flag=0
M205 VSSO 80 81 VSSO N5 L=6e-07 W=1e-05 rf_flag=0
M206 81 53 VSSO VSSO N5 L=6e-07 W=1e-05 rf_flag=0
M207 64 77 118 VSSO N5 L=6e-07 W=1e-05 rf_flag=0
M208 118 77 64 VSSO N5 L=6e-07 W=1e-05 rf_flag=0
M209 64 77 118 VSSO N5 L=6e-07 W=1e-05 rf_flag=0
M210 VSSO 80 66 VSSO N5 L=6e-07 W=7.5e-06 rf_flag=0
M211 66 80 VSSO VSSO N5 L=6e-07 W=7.5e-06 rf_flag=0
M212 VSSO 72 70 VSSO N5 L=6e-07 W=7.5e-06 rf_flag=0
M213 70 72 VSSO VSSO N5 L=6e-07 W=7.5e-06 rf_flag=0
M214 110 82 VSS VSS N5 L=6e-07 W=3.5e-06 rf_flag=0
M215 VSSO 81 52 VSSO N5 L=6e-07 W=7.5e-06 rf_flag=0
M216 52 81 VSSO VSSO N5 L=6e-07 W=7.5e-06 rf_flag=0
M217 VSS 82 110 VSS N5 L=6e-07 W=3.5e-06 rf_flag=0
M218 VSSO 40 71 VSSO N5 L=6e-07 W=7.5e-06 rf_flag=0
M219 71 40 VSSO VSSO N5 L=6e-07 W=7.5e-06 rf_flag=0
M220 110 82 VSS VSS N5 L=6e-07 W=3.5e-06 rf_flag=0
M221 118 71 VSSO VSSO N5 L=6e-07 W=5e-06 rf_flag=0
M222 73 79 VSS VSS N5 L=6e-07 W=5e-06 rf_flag=0
M223 VSS 79 73 VSS N5 L=6e-07 W=5e-06 rf_flag=0
M224 119 85 VSSO VSSO N5 L=6e-07 W=6.67e-06 rf_flag=0
M225 VSSO 85 119 VSSO N5 L=6e-07 W=6.67e-06 rf_flag=0
M226 119 85 VSSO VSSO N5 L=6e-07 W=6.67e-06 rf_flag=0
M227 80 86 VSSO VSSO N5 L=6e-07 W=5e-06 rf_flag=0
M228 VSSO 86 80 VSSO N5 L=6e-07 W=5e-06 rf_flag=0
M229 80 86 VSSO VSSO N5 L=6e-07 W=5e-06 rf_flag=0
M230 119 25 86 VSSO N5 L=6e-07 W=4e-06 rf_flag=0
M231 86 25 119 VSSO N5 L=6e-07 W=4e-06 rf_flag=0
M232 119 25 86 VSSO N5 L=6e-07 W=4e-06 rf_flag=0
M233 86 25 119 VSSO N5 L=6e-07 W=4e-06 rf_flag=0
M234 119 25 86 VSSO N5 L=6e-07 W=4e-06 rf_flag=0
M235 89 DRIVE_STR VSSO VSSO N5 L=6e-07 W=3e-06 rf_flag=0
M236 VSSO DRIVE_STR 89 VSSO N5 L=6e-07 W=3e-06 rf_flag=0
M237 89 DRIVE_STR VSSO VSSO N5 L=6e-07 W=3e-06 rf_flag=0
M238 85 DRIVE_STR VSS VSS N5 L=6e-07 W=5e-06 rf_flag=0
M239 VSS DRIVE_STR 85 VSS N5 L=6e-07 W=5e-06 rf_flag=0
M240 VDDO 6 7 VDDO P5 L=5e-07 W=1e-05 rf_flag=0
M241 6 21 VDDO VDDO P5 L=5e-07 W=1e-05 rf_flag=0
M242 94 6 VDDO VDDO P5 L=5e-07 W=1e-05 rf_flag=0
M243 VDDO 6 94 VDDO P5 L=5e-07 W=1e-05 rf_flag=0
M244 15 7 VDDO VDDO P5 L=5e-07 W=1e-05 rf_flag=0
M245 VDDO 7 15 VDDO P5 L=5e-07 W=1e-05 rf_flag=0
M246 15 8 95 VDDO P5 L=5e-07 W=1e-05 rf_flag=0
M247 95 8 15 VDDO P5 L=5e-07 W=1e-05 rf_flag=0
M248 95 6 93 VDDO P5 L=5e-07 W=1e-05 rf_flag=0
M249 93 6 95 VDDO P5 L=5e-07 W=1e-05 rf_flag=0
M250 95 6 93 VDDO P5 L=5e-07 W=1e-05 rf_flag=0
M251 93 6 95 VDDO P5 L=5e-07 W=1e-05 rf_flag=0
M252 93 9 VDDO VDDO P5 L=5e-07 W=1e-05 rf_flag=0
M253 VDDO 9 93 VDDO P5 L=5e-07 W=1e-05 rf_flag=0
M254 27 IE VDD VDD P5 L=5e-07 W=5e-06 rf_flag=0
M255 VDD IE 27 VDD P5 L=5e-07 W=5e-06 rf_flag=0
M256 98 30 21 VDDO P5 L=5e-07 W=5e-06 rf_flag=0
M257 24 25 VDDO VDDO P5 L=5e-07 W=5e-06 rf_flag=0
M258 VDDO 25 24 VDDO P5 L=5e-07 W=5e-06 rf_flag=0
M259 98 24 VDDO VDDO P5 L=5e-07 W=5e-06 rf_flag=0
M260 VDDO 24 98 VDDO P5 L=5e-07 W=5e-06 rf_flag=0
M261 98 24 VDDO VDDO P5 L=5e-07 W=5e-06 rf_flag=0
M262 VDDO 21 30 VDDO P5 L=5e-07 W=2e-06 rf_flag=0
M263 VDD SCHM_ON 33 VDD P5 L=5e-07 W=5e-06 rf_flag=0
M264 33 SCHM_ON VDD VDD P5 L=5e-07 W=5e-06 rf_flag=0
M265 VDDO 11 62 VDDO P5 L=5e-07 W=6e-06 rf_flag=0
M266 97 11 VDDO VDDO P5 L=5e-07 W=1e-05 rf_flag=0
M267 VDDO 29 99 VDDO P5 L=5e-07 W=1e-05 rf_flag=0
M268 99 29 VDDO VDDO P5 L=5e-07 W=1e-05 rf_flag=0
M269 40 31 VDDO VDDO P5 L=5e-07 W=6.67e-06 rf_flag=0
M270 VDDO 31 40 VDDO P5 L=5e-07 W=6.67e-06 rf_flag=0
M271 40 31 VDDO VDDO P5 L=5e-07 W=6.67e-06 rf_flag=0
M272 VDDO 25 38 VDDO P5 L=5e-07 W=5e-06 rf_flag=0
M273 VDDO 35 31 VDDO P5 L=5e-07 W=5e-06 rf_flag=0
M274 VDD EN 36 VDD P5 L=5e-07 W=5e-06 rf_flag=0
M275 36 EN VDD VDD P5 L=5e-07 W=5e-06 rf_flag=0
M276 VDDO 31 35 VDDO P5 L=5e-07 W=2e-06 rf_flag=0
M277 VDD I 42 VDD P5 L=5e-07 W=5e-06 rf_flag=0
M278 42 I VDD VDD P5 L=5e-07 W=5e-06 rf_flag=0
M279 VDDO 39 41 VDDO P5 L=5e-07 W=2e-06 rf_flag=0
M280 102 40 11 VDDO P5 L=5e-07 W=1.5e-05 rf_flag=0
M281 103 47 102 VDDO P5 L=5e-07 W=1.5e-05 rf_flag=0
M282 VDDO 46 103 VDDO P5 L=5e-07 W=1.5e-05 rf_flag=0
M283 39 25 VDDO VDDO P5 L=5e-07 W=5e-06 rf_flag=0
M284 VDDO 25 44 VDDO P5 L=5e-07 W=5e-06 rf_flag=0
M285 39 41 VDDO VDDO P5 L=5e-07 W=5e-06 rf_flag=0
M286 VDDO 39 47 VDDO P5 L=5e-07 W=1e-05 rf_flag=0
M287 47 39 VDDO VDDO P5 L=5e-07 W=1e-05 rf_flag=0
M288 14 PULL_UP_DOWN 105 VDD P5 L=5e-07 W=4e-06 rf_flag=0
M289 105 PULL_UP_DOWN 14 VDD P5 L=5e-07 W=4e-06 rf_flag=0
M290 VDD 45 105 VDD P5 L=5e-07 W=4e-06 rf_flag=0
M291 VDDO 49 55 VDDO P5 L=5e-07 W=6e-06 rf_flag=0
M292 49 44 VDDO VDDO P5 L=5e-07 W=5e-06 rf_flag=0
M293 VDDO 44 49 VDDO P5 L=5e-07 W=5e-06 rf_flag=0
M294 111 48 VDDO VDDO P5 L=5e-07 W=4.5e-06 rf_flag=0
M295 105 45 VDD VDD P5 L=5e-07 W=4e-06 rf_flag=0
M296 VDD PULL_ON 45 VDD P5 L=5e-07 W=5e-06 rf_flag=0
M297 45 PULL_ON VDD VDD P5 L=5e-07 W=5e-06 rf_flag=0
M298 VDD PULL_ON 79 VDD P5 L=5e-07 W=5e-06 rf_flag=0
M299 17 52 16 VDDO P5 L=5e-07 W=1e-05 rf_flag=0
M300 16 52 17 VDDO P5 L=5e-07 W=1e-05 rf_flag=0
M301 17 52 16 VDDO P5 L=5e-07 W=1e-05 rf_flag=0
M302 18 53 17 VDDO P5 L=5e-07 W=1e-05 rf_flag=0
M303 17 53 18 VDDO P5 L=5e-07 W=1e-05 rf_flag=0
M304 18 53 17 VDDO P5 L=5e-07 W=1e-05 rf_flag=0
M305 VDDO 53 18 VDDO P5 L=5e-07 W=1e-05 rf_flag=0
M306 18 53 VDDO VDDO P5 L=5e-07 W=1e-05 rf_flag=0
M307 VDDO 53 18 VDDO P5 L=5e-07 W=1e-05 rf_flag=0
M308 54 18 VDDO VDDO P5 L=5e-07 W=7.5e-06 rf_flag=0
M309 VDDO 54 46 VDDO P5 L=5e-07 W=7.5e-06 rf_flag=0
M310 46 54 VDDO VDDO P5 L=5e-07 W=7.5e-06 rf_flag=0
M311 79 PULL_ON VDD VDD P5 L=5e-07 W=5e-06 rf_flag=0
M312 VDD PULL_ON 79 VDD P5 L=5e-07 W=5e-06 rf_flag=0
M313 79 PULL_ON VDD VDD P5 L=5e-07 W=5e-06 rf_flag=0
M314 VDD PULL_UP_DOWN 79 VDD P5 L=5e-07 W=5e-06 rf_flag=0
M315 79 PULL_UP_DOWN VDD VDD P5 L=5e-07 W=5e-06 rf_flag=0
M316 VDD PULL_UP_DOWN 79 VDD P5 L=5e-07 W=5e-06 rf_flag=0
M317 79 PULL_UP_DOWN VDD VDD P5 L=5e-07 W=5e-06 rf_flag=0
M318 VDDO 59 44 VDDO P5 L=5e-07 W=5e-06 rf_flag=0
M319 VDDO 62 56 VDDO P5 L=5e-07 W=7.5e-06 rf_flag=0
M320 78 56 VDDO VDDO P5 L=5e-07 W=7.5e-06 rf_flag=0
M321 VDDO 56 78 VDDO P5 L=5e-07 W=7.5e-06 rf_flag=0
M322 VDD 58 CIN VDD P5 L=5e-07 W=5e-06 rf_flag=0
M323 CIN 58 VDD VDD P5 L=5e-07 W=5e-06 rf_flag=0
M324 VDD 58 CIN VDD P5 L=5e-07 W=5e-06 rf_flag=0
M325 59 44 VDDO VDDO P5 L=5e-07 W=2e-06 rf_flag=0
M326 CIN 58 VDD VDD P5 L=5e-07 W=5e-06 rf_flag=0
M327 48 15 VDDO VDDO P5 L=5e-07 W=1e-05 rf_flag=0
M328 15 49 111 VDDO P5 L=5e-07 W=9e-06 rf_flag=0
M329 58 60 VDD VDD P5 L=5e-07 W=5e-06 rf_flag=0
M330 VDD 63 58 VDD P5 L=1e-06 W=2.5e-06 rf_flag=0
M331 VDDO 15 82 VDDO P5 L=5e-07 W=5e-06 rf_flag=0
M332 82 15 VDDO VDDO P5 L=5e-07 W=5e-06 rf_flag=0
M333 97 64 84 VMAX P5 L=5e-07 W=1e-05 rf_flag=0
M334 84 64 97 VMAX P5 L=5e-07 W=1e-05 rf_flag=0
M335 VMAX 67 83 VMAX P5 L=5e-07 W=1e-05 rf_flag=0
M336 PAD 83 VDDO VMAX P5 L=5e-07 W=2.08e-05 rf_flag=0
M337 VDDO 83 PAD VMAX P5 L=5e-07 W=2.08e-05 rf_flag=0
M338 PAD 83 VDDO VMAX P5 L=5e-07 W=2.08e-05 rf_flag=0
M339 VDDO 83 PAD VMAX P5 L=5e-07 W=2.08e-05 rf_flag=0
M340 PAD 83 VDDO VMAX P5 L=5e-07 W=2.08e-05 rf_flag=0
M341 VDDO 83 PAD VMAX P5 L=5e-07 W=2.08e-05 rf_flag=0
M342 PAD 83 VDDO VMAX P5 L=5e-07 W=2.08e-05 rf_flag=0
M343 VDDO 83 PAD VMAX P5 L=5e-07 W=2.08e-05 rf_flag=0
M344 PAD 83 VDDO VMAX P5 L=5e-07 W=2.08e-05 rf_flag=0
M345 VDDO 83 PAD VMAX P5 L=5e-07 W=2.08e-05 rf_flag=0
M346 PAD 84 VDDO VMAX P5 L=5e-07 W=2.08e-05 rf_flag=0
M347 VDDO 84 PAD VMAX P5 L=5e-07 W=2.08e-05 rf_flag=0
M348 PAD 84 VDDO VMAX P5 L=5e-07 W=2.08e-05 rf_flag=0
M349 VDDO 84 PAD VMAX P5 L=5e-07 W=2.08e-05 rf_flag=0
M350 PAD 84 VDDO VMAX P5 L=5e-07 W=2.08e-05 rf_flag=0
M351 VDDO 84 PAD VMAX P5 L=5e-07 W=2.08e-05 rf_flag=0
M352 PAD 65 VDDO VMAX P5 L=5e-07 W=2.08e-05 rf_flag=0
M353 VDDO 65 PAD VMAX P5 L=5e-07 W=2.08e-05 rf_flag=0
M354 PAD 65 VDDO VMAX P5 L=5e-07 W=2.08e-05 rf_flag=0
M355 VDDO 65 PAD VMAX P5 L=5e-07 W=2.08e-05 rf_flag=0
M356 63 58 VDD VDD P5 L=6e-07 W=2.5e-06 rf_flag=0
M357 VDDO 61 29 VDDO P5 L=5e-07 W=7.5e-06 rf_flag=0
M358 29 61 VDDO VDDO P5 L=5e-07 W=7.5e-06 rf_flag=0
M359 61 66 VDDO VDDO P5 L=5e-07 W=7.5e-06 rf_flag=0
M360 VDDO 11 61 VDDO P5 L=5e-07 W=7.5e-06 rf_flag=0
M361 VDD 58 63 VDD P5 L=6e-07 W=2.5e-06 rf_flag=0
M362 99 64 83 VMAX P5 L=5e-07 W=1e-05 rf_flag=0
M363 83 64 99 VMAX P5 L=5e-07 W=1e-05 rf_flag=0
M364 99 64 83 VMAX P5 L=5e-07 W=1e-05 rf_flag=0
M365 62 64 65 VMAX P5 L=5e-07 W=1e-05 rf_flag=0
M366 65 64 62 VMAX P5 L=5e-07 W=1e-05 rf_flag=0
M367 9 67 64 VMAX P5 L=5e-07 W=5e-06 rf_flag=0
M368 64 67 9 VMAX P5 L=5e-07 W=5e-06 rf_flag=0
M369 9 67 64 VMAX P5 L=5e-07 W=5e-06 rf_flag=0
M370 64 67 9 VMAX P5 L=5e-07 W=5e-06 rf_flag=0
M371 VMAX 67 84 VMAX P5 L=5e-07 W=5e-06 rf_flag=0
M372 65 67 VMAX VMAX P5 L=5e-07 W=5e-06 rf_flag=0
M373 53 71 VDDO VDDO P5 L=5e-07 W=1.5e-05 rf_flag=0
M374 VDDO 47 53 VDDO P5 L=5e-07 W=1.5e-05 rf_flag=0
M375 53 78 VDDO VDDO P5 L=5e-07 W=1.5e-05 rf_flag=0
M376 VDDO 64 115 VMAX P5 L=6e-07 W=5e-06 rf_flag=0
M377 VDDO 72 70 VDDO P5 L=5e-07 W=1e-05 rf_flag=0
M378 70 72 VDDO VDDO P5 L=5e-07 W=1e-05 rf_flag=0
M379 72 75 VDDO VDDO P5 L=5e-07 W=5e-06 rf_flag=0
M380 VDDO 72 75 VDDO P5 L=5e-07 W=2e-06 rf_flag=0
M381 74 70 VDDO VDDO P5 L=5e-07 W=7e-06 rf_flag=0
M382 115 74 9 VMAX P5 L=4e-06 W=2.5e-06 rf_flag=0
M383 VMAX VMAX VDDO VMAX P5 L=5e-07 W=1.5e-05 rf_flag=0
M384 VDDO VMAX VMAX VMAX P5 L=5e-07 W=1.5e-05 rf_flag=0
M385 VMAX VMAX VDDO VMAX P5 L=5e-07 W=1.5e-05 rf_flag=0
M386 VDDO VMAX VMAX VMAX P5 L=5e-07 W=1.5e-05 rf_flag=0
M387 VMAX 9 VDDO VMAX P5 L=5e-07 W=1.5e-05 rf_flag=0
M388 9 67 VMAX VMAX P5 L=5e-07 W=1.5e-05 rf_flag=0
M389 VDDO 64 VMAX VMAX P5 L=5e-07 W=1.5e-05 rf_flag=0
M390 VMAX 64 VDDO VMAX P5 L=5e-07 W=1.5e-05 rf_flag=0
M391 VDDO 64 VMAX VMAX P5 L=5e-07 W=1.5e-05 rf_flag=0
M392 VMAX 64 VDDO VMAX P5 L=5e-07 W=1.5e-05 rf_flag=0
M393 VDDO 64 VMAX VMAX P5 L=5e-07 W=1.5e-05 rf_flag=0
M394 VMAX 64 VDDO VMAX P5 L=5e-07 W=1.5e-05 rf_flag=0
M395 VDDO 64 VMAX VMAX P5 L=5e-07 W=1.5e-05 rf_flag=0
M396 VMAX 64 VDDO VMAX P5 L=5e-07 W=1.5e-05 rf_flag=0
M397 8 23 9 VMAX P5 L=5e-07 W=1e-05 rf_flag=0
M398 9 23 8 VMAX P5 L=5e-07 W=1e-05 rf_flag=0
M399 23 10 9 VMAX P5 L=5e-07 W=1e-05 rf_flag=0
M400 VDDO 80 117 VDDO P5 L=5e-07 W=7.5e-06 rf_flag=0
M401 117 80 VDDO VDDO P5 L=5e-07 W=7.5e-06 rf_flag=0
M402 81 53 117 VDDO P5 L=5e-07 W=7.5e-06 rf_flag=0
M403 117 53 81 VDDO P5 L=5e-07 W=7.5e-06 rf_flag=0
M404 VDDO 80 66 VDDO P5 L=5e-07 W=6e-06 rf_flag=0
M405 66 80 VDDO VDDO P5 L=5e-07 W=6e-06 rf_flag=0
M406 VDDO 40 71 VDDO P5 L=5e-07 W=7.5e-06 rf_flag=0
M407 71 40 VDDO VDDO P5 L=5e-07 W=7.5e-06 rf_flag=0
M408 VDDO 81 52 VDDO P5 L=5e-07 W=1e-05 rf_flag=0
M409 52 81 VDDO VDDO P5 L=5e-07 W=1e-05 rf_flag=0
M410 73 79 VDD VDD P5 L=5e-07 W=5e-06 rf_flag=0
M411 VDD 79 73 VDD P5 L=5e-07 W=5e-06 rf_flag=0
M412 VDDO 86 80 VDDO P5 L=5e-07 W=4e-06 rf_flag=0
M413 80 86 VDDO VDDO P5 L=5e-07 W=4e-06 rf_flag=0
M414 VDDO 86 80 VDDO P5 L=5e-07 W=4e-06 rf_flag=0
M415 80 86 VDDO VDDO P5 L=5e-07 W=4e-06 rf_flag=0
M416 VDDO 86 80 VDDO P5 L=5e-07 W=4e-06 rf_flag=0
M417 86 89 VDDO VDDO P5 L=5e-07 W=5e-06 rf_flag=0
M418 89 86 VDDO VDDO P5 L=5e-07 W=2e-06 rf_flag=0
M419 86 25 VDDO VDDO P5 L=5e-07 W=5e-06 rf_flag=0
M420 85 DRIVE_STR VDD VDD P5 L=5e-07 W=5e-06 rf_flag=0
M421 VDD DRIVE_STR 85 VDD P5 L=5e-07 W=5e-06 rf_flag=0
R422 VSSO 13 1182.07 L=2.655e-06 W=1e-06 postlayout=1 $SUB=VSSO $[RD3]
R423 12 VDDO 1182.07 L=2.655e-06 W=1e-06 postlayout=1 $SUB=VSSO $[RD3]
R424 20 26 1372.42 L=3.25e-06 W=1e-06 postlayout=1 $SUB=VSSO $[RD3]
R425 20 VDDO 1372.42 L=3.25e-06 W=1e-06 postlayout=1 $SUB=VSSO $[RD3]
R426 34 51 1372.42 L=3.25e-06 W=1e-06 postlayout=1 $SUB=VSSO $[RD3]
R427 VDDO 51 1372.42 L=3.25e-06 W=1e-06 postlayout=1 $SUB=VSSO $[RD3]
R428 VDDO 77 2412.15 L=6.5e-06 W=1e-06 postlayout=1 $SUB=VSSO $[RD3]
R429 VDDO 10 972.524 L=2e-06 W=1e-06 postlayout=1 $SUB=VDDO $[RD3]
R430 PAD 69 307.767 L=2.9e-06 W=4e-06 postlayout=1 $SUB=VMAX $[RD3]
R431 60 VDD_OK 972.524 L=2e-06 W=1e-06 postlayout=1 $SUB=VDD $[RD3]
R432 69 9 307.767 L=2.9e-06 W=4e-06 postlayout=1 $SUB=VMAX $[RD3]
R433 VDDO 67 2412.15 L=6.5e-06 W=1e-06 postlayout=1 $SUB=VMAX $[RD3]
R434 25 VDDO_OK 972.524 L=2e-06 W=1e-06 postlayout=1 $SUB=VDD $[RD3]
D435 VSS VDD dwn2psub AREA=1.37174e-09 PJ=0.00051334
D436 VSS VDDO dwn2psub AREA=3.83476e-09 PJ=0.0006715
D437 VSS VDD dwn2psub AREA=1.37174e-09 PJ=0.00051334
D438 VSSO VDDO dwn2psub AREA=7.0561e-10 PJ=0.00069394
D439 VSSO VDDO dwn2psub AREA=3.83476e-09 PJ=0.0006715
D440 VSS VDDO dwn2psub AREA=7.0561e-10 PJ=0.00069394
D441 VSS VMAX dwn2psub AREA=4.53527e-09 PJ=0.00031038
.ENDS

.SUBCKT PIOL_NA_18 PAD VDDO VSSO VSS VDD PULL_UP_DOWN DRIVE_STR PULL_ON EN IE I SCHM_ON CIN
*.PININFO PAD:B VDDO:B VSSO:B VSS:B VDD:B PULL_UP_DOWN:I DRIVE_STR:I PULL_ON:I EN:I IE:I I:I SCHM_ON:I CIN:O
M0 11 VMAX VSS VSS N L=3e-06 W=5e-06 rf_flag=0
M1 PAD 11 VSS VSS N L=2.5e-07 W=2.4e-05 rf_flag=0
M2 VSS 8 PAD VSS N L=2.5e-07 W=2.4e-05 rf_flag=0
M3 PAD 11 VSS VSS N L=2.5e-07 W=2.4e-05 rf_flag=0
M4 VSS 8 PAD VSS N L=2.5e-07 W=2.4e-05 rf_flag=0
M5 PAD 11 VSS VSS N L=2.5e-07 W=2.4e-05 rf_flag=0
M6 VSS 8 PAD VSS N L=2.5e-07 W=2.4e-05 rf_flag=0
M7 PAD 11 VSS VSS N L=2.5e-07 W=2.4e-05 rf_flag=0
M8 VSS 9 PAD VSS N L=2.5e-07 W=2.4e-05 rf_flag=0
M9 PAD 11 VSS VSS N L=2.5e-07 W=2.4e-05 rf_flag=0
M10 VSS 9 PAD VSS N L=2.5e-07 W=2.4e-05 rf_flag=0
M11 PAD 11 VSS VSS N L=2.5e-07 W=2.4e-05 rf_flag=0
M12 VSS 9 PAD VSS N L=2.5e-07 W=2.4e-05 rf_flag=0
M13 PAD 11 VSS VSS N L=2.5e-07 W=2.4e-05 rf_flag=0
M14 VSS 10 PAD VSS N L=2.5e-07 W=2.4e-05 rf_flag=0
M15 PAD 11 VSS VSS N L=2.5e-07 W=2.4e-05 rf_flag=0
M16 VSS 10 PAD VSS N L=2.5e-07 W=2.4e-05 rf_flag=0
M17 CIN 26 VSS VSS N L=1.8e-07 W=1.5e-05 rf_flag=0
M18 VSS 12 37 VSS N L=2.5e-07 W=1e-05 rf_flag=0
M19 37 12 VSS VSS N L=2.5e-07 W=1e-05 rf_flag=0
M20 23 42 VSS VSS N L=1.8e-07 W=1e-05 rf_flag=0
M21 VSS 34 48 VSS N L=1.8e-07 W=1e-05 rf_flag=0
M22 VSS 13 40 VSS N L=1.8e-07 W=1e-05 rf_flag=0
M23 40 18 VSS VSS N L=1.8e-07 W=1e-05 rf_flag=0
M24 VSS 35 21 VSS N L=1.8e-07 W=1e-05 rf_flag=0
M25 VSS 14 43 VSS N L=1.8e-07 W=1e-05 rf_flag=0
M26 43 14 VSS VSS N L=1.8e-07 W=1e-05 rf_flag=0
M27 VSS 15 37 VSS N L=8e-06 W=1.5e-06 rf_flag=0
M28 36 27 VSS VSS N L=1.8e-07 W=5e-06 rf_flag=0
M29 VSS 27 36 VSS N L=1.8e-07 W=5e-06 rf_flag=0
M30 36 27 VSS VSS N L=1.8e-07 W=5e-06 rf_flag=0
M31 VSS 27 36 VSS N L=1.8e-07 W=5e-06 rf_flag=0
M32 36 27 VSS VSS N L=1.8e-07 W=5e-06 rf_flag=0
M33 VSS 27 36 VSS N L=1.8e-07 W=5e-06 rf_flag=0
M34 53 PULL_UP_DOWN 41 VSS N L=1.8e-07 W=7e-06 rf_flag=0
M35 VSS PULL_ON 53 VSS N L=1.8e-07 W=7e-06 rf_flag=0
M36 17 PULL_ON VSS VSS N L=1.8e-07 W=7e-06 rf_flag=0
M37 VSS 17 15 VSS N L=1.8e-07 W=7.5e-06 rf_flag=0
M38 15 17 VSS VSS N L=1.8e-07 W=7.5e-06 rf_flag=0
M39 VSS PULL_UP_DOWN 15 VSS N L=1.8e-07 W=7.5e-06 rf_flag=0
M40 15 PULL_UP_DOWN VSS VSS N L=1.8e-07 W=7.5e-06 rf_flag=0
M41 10 18 VSS VSS N L=1.8e-07 W=7.5e-06 rf_flag=0
M42 VSS 18 10 VSS N L=1.8e-07 W=7.5e-06 rf_flag=0
M43 VSS 19 8 VSS N L=1.8e-07 W=7.5e-06 rf_flag=0
M44 8 19 VSS VSS N L=1.8e-07 W=7.5e-06 rf_flag=0
M45 VSS 19 8 VSS N L=1.8e-07 W=7.5e-06 rf_flag=0
M46 8 19 VSS VSS N L=1.8e-07 W=7.5e-06 rf_flag=0
M47 VSS 34 52 VSS N L=1.8e-07 W=7.5e-06 rf_flag=0
M48 52 34 VSS VSS N L=1.8e-07 W=7.5e-06 rf_flag=0
M49 54 20 52 VSS N L=1.8e-07 W=7.5e-06 rf_flag=0
M50 52 20 54 VSS N L=1.8e-07 W=7.5e-06 rf_flag=0
M51 54 21 18 VSS N L=1.8e-07 W=7.5e-06 rf_flag=0
M52 18 21 54 VSS N L=1.8e-07 W=7.5e-06 rf_flag=0
M53 VSS 40 19 VSS N L=1.8e-07 W=7.5e-06 rf_flag=0
M54 19 40 VSS VSS N L=1.8e-07 W=7.5e-06 rf_flag=0
M55 VSS 22 34 VSS N L=1.8e-07 W=7.5e-06 rf_flag=0
M56 34 22 VSS VSS N L=1.8e-07 W=7.5e-06 rf_flag=0
M57 VSS DRIVE_STR 13 VSS N L=1.8e-07 W=7.5e-06 rf_flag=0
M58 13 DRIVE_STR VSS VSS N L=1.8e-07 W=7.5e-06 rf_flag=0
M59 VSS 22 27 VSS N L=1.8e-07 W=7.5e-06 rf_flag=0
M60 27 22 VSS VSS N L=1.8e-07 W=7.5e-06 rf_flag=0
M61 VSS 20 27 VSS N L=1.8e-07 W=7.5e-06 rf_flag=0
M62 27 20 VSS VSS N L=1.8e-07 W=7.5e-06 rf_flag=0
M63 VSS 23 27 VSS N L=1.8e-07 W=7.5e-06 rf_flag=0
M64 27 23 VSS VSS N L=1.8e-07 W=7.5e-06 rf_flag=0
M65 VSS EN 22 VSS N L=1.8e-07 W=7.5e-06 rf_flag=0
M66 22 EN VSS VSS N L=1.8e-07 W=7.5e-06 rf_flag=0
M67 VSS 18 9 VSS N L=1.8e-07 W=7.5e-06 rf_flag=0
M68 9 18 VSS VSS N L=1.8e-07 W=7.5e-06 rf_flag=0
M69 VSS I 20 VSS N L=1.8e-07 W=7.5e-06 rf_flag=0
M70 20 I VSS VSS N L=1.8e-07 W=7.5e-06 rf_flag=0
M71 62 37 26 VSS N L=1.8e-07 W=7e-06 rf_flag=0
M72 VSS IE 62 VSS N L=1.8e-07 W=7e-06 rf_flag=0
M73 VSS 29 47 VSS N L=1.8e-07 W=5e-06 rf_flag=0
M74 VSS 41 29 VSS N L=1.8e-07 W=5e-06 rf_flag=0
M75 14 DRIVE_STR 55 VSS N L=1.8e-07 W=5e-06 rf_flag=0
M76 55 DRIVE_STR 14 VSS N L=1.8e-07 W=5e-06 rf_flag=0
M77 VSS 27 55 VSS N L=1.8e-07 W=5e-06 rf_flag=0
M78 55 27 VSS VSS N L=1.8e-07 W=5e-06 rf_flag=0
M79 VSS 30 28 VSS N L=1.8e-07 W=5e-06 rf_flag=0
M80 VSS 10 42 VSS N L=1.8e-07 W=5e-06 rf_flag=0
M81 VSS 36 35 VSS N L=1.8e-07 W=5e-06 rf_flag=0
M82 46 IE VSS VSS N L=1.8e-07 W=5e-06 rf_flag=0
M83 VSS 26 33 VSS N L=1.8e-07 W=5e-06 rf_flag=0
M84 VSS SCHM_ON 30 VSS N L=1.8e-07 W=2.5e-06 rf_flag=0
M85 63 33 VSS VSS N L=1.8e-07 W=2e-06 rf_flag=0
M86 26 28 63 VSS N L=1.8e-07 W=2e-06 rf_flag=0
M87 49 43 50 VSS N L=1.8e-07 W=5e-06 rf_flag=0
M88 50 43 49 VSS N L=1.8e-07 W=5e-06 rf_flag=0
M89 49 43 50 VSS N L=1.8e-07 W=5e-06 rf_flag=0
M90 50 43 49 VSS N L=1.8e-07 W=5e-06 rf_flag=0
M91 49 43 50 VSS N L=1.8e-07 W=5e-06 rf_flag=0
M92 50 43 49 VSS N L=1.8e-07 W=5e-06 rf_flag=0
M93 36 27 50 VSS N L=1.8e-07 W=5e-06 rf_flag=0
M94 50 27 36 VSS N L=1.8e-07 W=5e-06 rf_flag=0
M95 36 27 50 VSS N L=1.8e-07 W=5e-06 rf_flag=0
M96 50 27 36 VSS N L=1.8e-07 W=5e-06 rf_flag=0
M97 36 27 50 VSS N L=1.8e-07 W=5e-06 rf_flag=0
M98 50 27 36 VSS N L=1.8e-07 W=5e-06 rf_flag=0
M99 PAD 49 VDD VMAX P L=2.5e-07 W=2.08e-05 rf_flag=0
M100 VDD 49 PAD VMAX P L=2.5e-07 W=2.08e-05 rf_flag=0
M101 PAD 49 VDD VMAX P L=2.5e-07 W=2.08e-05 rf_flag=0
M102 VDD 49 PAD VMAX P L=2.5e-07 W=2.08e-05 rf_flag=0
M103 PAD 49 VDD VMAX P L=2.5e-07 W=2.08e-05 rf_flag=0
M104 VDD 49 PAD VMAX P L=2.5e-07 W=2.08e-05 rf_flag=0
M105 PAD 49 VDD VMAX P L=2.5e-07 W=2.08e-05 rf_flag=0
M106 VDD 49 PAD VMAX P L=2.5e-07 W=2.08e-05 rf_flag=0
M107 PAD 49 VDD VMAX P L=2.5e-07 W=2.08e-05 rf_flag=0
M108 VDD 49 PAD VMAX P L=2.5e-07 W=2.08e-05 rf_flag=0
M109 PAD 50 VDD VMAX P L=2.5e-07 W=2.08e-05 rf_flag=0
M110 VDD 50 PAD VMAX P L=2.5e-07 W=2.08e-05 rf_flag=0
M111 PAD 50 VDD VMAX P L=2.5e-07 W=2.08e-05 rf_flag=0
M112 VDD 50 PAD VMAX P L=2.5e-07 W=2.08e-05 rf_flag=0
M113 PAD 50 VDD VMAX P L=2.5e-07 W=2.08e-05 rf_flag=0
M114 VDD 50 PAD VMAX P L=2.5e-07 W=2.08e-05 rf_flag=0
M115 PAD 36 VDD VMAX P L=2.5e-07 W=2.08e-05 rf_flag=0
M116 VDD 36 PAD VMAX P L=2.5e-07 W=2.08e-05 rf_flag=0
M117 PAD 36 VDD VMAX P L=2.5e-07 W=2.08e-05 rf_flag=0
M118 VDD 36 PAD VMAX P L=2.5e-07 W=2.08e-05 rf_flag=0
M119 56 22 27 VDD P L=1.8e-07 W=1.5e-05 rf_flag=0
M120 57 20 56 VDD P L=1.8e-07 W=1.5e-05 rf_flag=0
M121 VDD 23 57 VDD P L=1.8e-07 W=1.5e-05 rf_flag=0
M122 VMAX 44 37 VMAX P L=1.8e-07 W=7.5e-06 rf_flag=0
M123 37 44 VMAX VMAX P L=1.8e-07 W=7.5e-06 rf_flag=0
M124 VMAX 43 49 VMAX P L=1.8e-07 W=1e-05 rf_flag=0
M125 49 43 VMAX VMAX P L=1.8e-07 W=1e-05 rf_flag=0
M126 50 27 VMAX VMAX P L=1.8e-07 W=1e-05 rf_flag=0
M127 VMAX 27 36 VMAX P L=1.8e-07 W=6e-06 rf_flag=0
M128 VDD VMAX VMAX VMAX P L=1.8e-07 W=1e-05 rf_flag=0
M129 VMAX VMAX VDD VMAX P L=1.8e-07 W=1e-05 rf_flag=0
M130 VDD VMAX VMAX VMAX P L=1.8e-07 W=1e-05 rf_flag=0
M131 VMAX 29 47 VMAX P L=1.8e-07 W=7e-06 rf_flag=0
M132 VMAX 37 VDD VMAX P L=1.8e-07 W=7.5e-06 rf_flag=0
M133 VDD 37 VMAX VMAX P L=1.8e-07 W=7.5e-06 rf_flag=0
M134 26 37 59 VDD P L=1.8e-07 W=1e-05 rf_flag=0
M135 59 37 26 VDD P L=1.8e-07 W=1e-05 rf_flag=0
M136 VMAX 34 18 VMAX P L=1.8e-07 W=7.5e-06 rf_flag=0
M137 18 34 VMAX VMAX P L=1.8e-07 W=7.5e-06 rf_flag=0
M138 VMAX 20 18 VMAX P L=1.8e-07 W=7.5e-06 rf_flag=0
M139 18 20 VMAX VMAX P L=1.8e-07 W=7.5e-06 rf_flag=0
M140 VMAX 21 18 VMAX P L=1.8e-07 W=7.5e-06 rf_flag=0
M141 18 21 VMAX VMAX P L=1.8e-07 W=7.5e-06 rf_flag=0
M142 VDD EN 22 VDD P L=1.8e-07 W=1e-05 rf_flag=0
M143 22 EN VDD VDD P L=1.8e-07 W=1e-05 rf_flag=0
M144 VDD 35 21 VDD P L=1.8e-07 W=7.5e-06 rf_flag=0
M145 21 35 VDD VDD P L=1.8e-07 W=7.5e-06 rf_flag=0
M146 VDD 36 35 VDD P L=1.8e-07 W=7.5e-06 rf_flag=0
M147 VDD 26 CIN VDD P L=1.8e-07 W=1e-05 rf_flag=0
M148 CIN 26 VDD VDD P L=1.8e-07 W=1e-05 rf_flag=0
M149 VDD I 20 VDD P L=1.8e-07 W=1e-05 rf_flag=0
M150 20 I VDD VDD P L=1.8e-07 W=1e-05 rf_flag=0
M151 VDD IE 26 VDD P L=1.8e-07 W=5e-06 rf_flag=0
M152 46 IE VDD VDD P L=1.8e-07 W=6e-06 rf_flag=0
M153 VDD 26 33 VDD P L=1.8e-07 W=1e-05 rf_flag=0
M154 58 33 VDD VDD P L=1.8e-07 W=4.5e-06 rf_flag=0
M155 58 30 26 VDD P L=1.8e-07 W=4.5e-06 rf_flag=0
M156 VDD 30 28 VDD P L=1.8e-07 W=6e-06 rf_flag=0
M157 30 SCHM_ON VDD VDD P L=1.8e-07 W=5e-06 rf_flag=0
M158 59 46 VDD VDD P L=1.8e-07 W=1e-05 rf_flag=0
M159 VDD 46 59 VDD P L=1.8e-07 W=1e-05 rf_flag=0
M160 14 DRIVE_STR VDD VDD P L=1.8e-07 W=7.5e-06 rf_flag=0
M161 VDD 27 14 VDD P L=1.8e-07 W=7.5e-06 rf_flag=0
M162 40 18 60 VDD P L=1.8e-07 W=7.5e-06 rf_flag=0
M163 60 18 40 VDD P L=1.8e-07 W=7.5e-06 rf_flag=0
M164 VDD 13 60 VDD P L=1.8e-07 W=7.5e-06 rf_flag=0
M165 60 13 VDD VDD P L=1.8e-07 W=7.5e-06 rf_flag=0
M166 VDD 22 34 VDD P L=1.8e-07 W=7.5e-06 rf_flag=0
M167 34 22 VDD VDD P L=1.8e-07 W=7.5e-06 rf_flag=0
M168 VDD DRIVE_STR 13 VDD P L=1.8e-07 W=6e-06 rf_flag=0
M169 13 DRIVE_STR VDD VDD P L=1.8e-07 W=6e-06 rf_flag=0
M170 VDD 14 43 VDD P L=1.8e-07 W=7.5e-06 rf_flag=0
M171 43 14 VDD VDD P L=1.8e-07 W=7.5e-06 rf_flag=0
M172 VDD 41 29 VDD P L=1.8e-07 W=7e-06 rf_flag=0
M173 VDD 10 42 VDD P L=1.8e-07 W=7.5e-06 rf_flag=0
M174 VDD 18 10 VDD P L=1.8e-07 W=7.5e-06 rf_flag=0
M175 10 18 VDD VDD P L=1.8e-07 W=7.5e-06 rf_flag=0
M176 VDD 18 10 VDD P L=1.8e-07 W=7.5e-06 rf_flag=0
M177 10 18 VDD VDD P L=1.8e-07 W=7.5e-06 rf_flag=0
M178 9 18 10 VDD P L=1.8e-07 W=7.5e-06 rf_flag=0
M179 10 18 9 VDD P L=1.8e-07 W=7.5e-06 rf_flag=0
M180 9 18 10 VDD P L=1.8e-07 W=7.5e-06 rf_flag=0
M181 10 18 9 VDD P L=1.8e-07 W=7.5e-06 rf_flag=0
M182 9 19 8 VDD P L=1.8e-07 W=7.5e-06 rf_flag=0
M183 8 19 9 VDD P L=1.8e-07 W=7.5e-06 rf_flag=0
M184 9 19 8 VDD P L=1.8e-07 W=7.5e-06 rf_flag=0
M185 8 19 9 VDD P L=1.8e-07 W=7.5e-06 rf_flag=0
M186 VDD 42 23 VDD P L=1.8e-07 W=7.5e-06 rf_flag=0
M187 23 42 VDD VDD P L=1.8e-07 W=7.5e-06 rf_flag=0
M188 VDD PULL_UP_DOWN 41 VDD P L=1.8e-07 W=5e-06 rf_flag=0
M189 41 PULL_UP_DOWN VDD VDD P L=1.8e-07 W=5e-06 rf_flag=0
M190 VDD PULL_UP_DOWN 41 VDD P L=1.8e-07 W=5e-06 rf_flag=0
M191 41 PULL_UP_DOWN VDD VDD P L=1.8e-07 W=5e-06 rf_flag=0
M192 VDD PULL_ON 41 VDD P L=1.8e-07 W=5e-06 rf_flag=0
M193 41 PULL_ON VDD VDD P L=1.8e-07 W=5e-06 rf_flag=0
M194 VDD PULL_ON 41 VDD P L=1.8e-07 W=5e-06 rf_flag=0
M195 41 PULL_ON VDD VDD P L=1.8e-07 W=5e-06 rf_flag=0
M196 VDD PULL_ON 17 VDD P L=1.8e-07 W=5e-06 rf_flag=0
M197 17 PULL_ON VDD VDD P L=1.8e-07 W=5e-06 rf_flag=0
M198 VDD 17 61 VDD P L=1.8e-07 W=4e-06 rf_flag=0
M199 61 17 VDD VDD P L=1.8e-07 W=4e-06 rf_flag=0
M200 15 PULL_UP_DOWN 61 VDD P L=1.8e-07 W=4e-06 rf_flag=0
M201 61 PULL_UP_DOWN 15 VDD P L=1.8e-07 W=4e-06 rf_flag=0
M202 37 47 VDD VMAX P L=4e-06 W=2.5e-06 rf_flag=0
M203 VDD VMAX VMAX VMAX P L=1.8e-07 W=1e-05 rf_flag=0
M204 VMAX VMAX VDD VMAX P L=1.8e-07 W=1e-05 rf_flag=0
M205 VDD VMAX VMAX VMAX P L=1.8e-07 W=1e-05 rf_flag=0
M206 VMAX 34 48 VMAX P L=1.8e-07 W=1e-05 rf_flag=0
M207 VMAX 40 19 VMAX P L=1.8e-07 W=1e-05 rf_flag=0
M208 19 40 VMAX VMAX P L=1.8e-07 W=1e-05 rf_flag=0
M209 VDD 48 VMAX VMAX P L=1.8e-07 W=7.5e-06 rf_flag=0
M210 VMAX 48 VDD VMAX P L=1.8e-07 W=7.5e-06 rf_flag=0
M211 VDD 48 VMAX VMAX P L=1.8e-07 W=7.5e-06 rf_flag=0
M212 VMAX 48 VDD VMAX P L=1.8e-07 W=7.5e-06 rf_flag=0
M213 VDD 48 VMAX VMAX P L=1.8e-07 W=7.5e-06 rf_flag=0
M214 VMAX 48 VDD VMAX P L=1.8e-07 W=7.5e-06 rf_flag=0
M215 VDD 48 VMAX VMAX P L=1.8e-07 W=7.5e-06 rf_flag=0
M216 VMAX 48 VDD VMAX P L=1.8e-07 W=7.5e-06 rf_flag=0
M217 VDD 48 VMAX VMAX P L=1.8e-07 W=7.5e-06 rf_flag=0
M218 VMAX 48 VDD VMAX P L=1.8e-07 W=7.5e-06 rf_flag=0
M219 VDD 48 VMAX VMAX P L=1.8e-07 W=7.5e-06 rf_flag=0
M220 VMAX 48 VDD VMAX P L=1.8e-07 W=7.5e-06 rf_flag=0
M221 VDD 48 VMAX VMAX P L=1.8e-07 W=7.5e-06 rf_flag=0
M222 VMAX 48 VDD VMAX P L=1.8e-07 W=7.5e-06 rf_flag=0
M223 VDD 48 VMAX VMAX P L=1.8e-07 W=7.5e-06 rf_flag=0
M224 VMAX 48 VDD VMAX P L=1.8e-07 W=7.5e-06 rf_flag=0
M225 VDD 48 VMAX VMAX P L=1.8e-07 W=7.5e-06 rf_flag=0
M226 VMAX 48 VDD VMAX P L=1.8e-07 W=7.5e-06 rf_flag=0
M227 VDD 48 VMAX VMAX P L=1.8e-07 W=7.5e-06 rf_flag=0
M228 VMAX 48 VDD VMAX P L=1.8e-07 W=7.5e-06 rf_flag=0
M229 VDD 48 VMAX VMAX P L=1.8e-07 W=7.5e-06 rf_flag=0
M230 VMAX 48 VDD VMAX P L=1.8e-07 W=7.5e-06 rf_flag=0
M231 VDD 48 VMAX VMAX P L=1.8e-07 W=7.5e-06 rf_flag=0
M232 VMAX 48 VDD VMAX P L=1.8e-07 W=7.5e-06 rf_flag=0
R233 12 VSS 1180.47 L=2.65e-06 W=1e-06 postlayout=1 $SUB=VSS $[RD3]
R234 PAD 45 307.767 L=2.9e-06 W=4e-06 postlayout=1 $SUB=VMAX $[RD3]
R235 45 37 307.767 L=2.9e-06 W=4e-06 postlayout=1 $SUB=VMAX $[RD3]
R236 44 VDD 2412.15 L=6.5e-06 W=1e-06 postlayout=1 $SUB=VMAX $[RD3]
D237 VSS VDD dwn2psub AREA=4.73885e-09 PJ=0.00064473
D238 VSS VDD dwn2psub AREA=7.56483e-10 PJ=0.00063777
D239 VSS VDD dwn2psub AREA=4.73885e-09 PJ=0.00064473
D240 VSS VDD dwn2psub AREA=7.56483e-10 PJ=0.00063777
D241 VSS VMAX dwn2psub AREA=4.53839e-09 PJ=0.00031054
D242 VSS PAD dnpwcpl18 AREA=4.2e-11 PJ=4.42e-05 nf=1
D243 VSS PAD dnpwcpl18 AREA=4.2e-11 PJ=4.42e-05 nf=1
.ENDS

.SUBCKT POK_18_18 VDDO VSSO VSS VDD VDDO_OK VDD_OK
*.PININFO VDDO:B VSSO:B VSS:B VDD:B VDDO_OK:O VDD_OK:O
M0 VDDO_OK 7 VSSO VSSO N L=6e-07 W=1.5e-06 rf_flag=0
M1 VDD_OK 8 VSS VSS N L=6e-07 W=1.5e-06 rf_flag=0
M2 VSSO 7 VDDO_OK VSSO N L=6e-07 W=1.5e-06 rf_flag=0
M3 VSS 8 VDD_OK VSS N L=6e-07 W=1.5e-06 rf_flag=0
M4 VDDO_OK 7 VSSO VSSO N L=6e-07 W=1.5e-06 rf_flag=0
M5 VDD_OK 8 VSS VSS N L=6e-07 W=1.5e-06 rf_flag=0
M6 VSSO 7 VDDO_OK VSSO N L=6e-07 W=1.5e-06 rf_flag=0
M7 VSS 8 VDD_OK VSS N L=6e-07 W=1.5e-06 rf_flag=0
M8 VDDO_OK 7 VSSO VSSO N L=6e-07 W=1.5e-06 rf_flag=0
M9 VDD_OK 8 VSS VSS N L=6e-07 W=1.5e-06 rf_flag=0
M10 VSSO 7 VDDO_OK VSSO N L=6e-07 W=1.5e-06 rf_flag=0
M11 VSS 8 VDD_OK VSS N L=6e-07 W=1.5e-06 rf_flag=0
M12 VDDO_OK 7 VSSO VSSO N L=6e-07 W=1.5e-06 rf_flag=0
M13 VDD_OK 8 VSS VSS N L=6e-07 W=1.5e-06 rf_flag=0
M14 VSSO 7 VDDO_OK VSSO N L=6e-07 W=1.5e-06 rf_flag=0
M15 VSS 8 VDD_OK VSS N L=6e-07 W=1.5e-06 rf_flag=0
M16 VDDO_OK 7 VSSO VSSO N L=6e-07 W=1.5e-06 rf_flag=0
M17 VDD_OK 8 VSS VSS N L=6e-07 W=1.5e-06 rf_flag=0
M18 VSSO 7 VDDO_OK VSSO N L=6e-07 W=1.5e-06 rf_flag=0
M19 VSS 8 VDD_OK VSS N L=6e-07 W=1.5e-06 rf_flag=0
M20 7 9 VSSO VSSO N L=6e-07 W=5e-06 rf_flag=0
M21 8 10 VSS VSS N L=6e-07 W=5e-06 rf_flag=0
M22 VSSO 9 7 VSSO N L=6e-07 W=5e-06 rf_flag=0
M23 VSS 10 8 VSS N L=6e-07 W=5e-06 rf_flag=0
M24 29 5 11 VDDO P L=1e-05 W=1e-06 rf_flag=0
M25 21 5 11 VDDO P L=1e-05 W=1e-06 rf_flag=0
M26 21 5 12 VDDO P L=1e-05 W=1e-06 rf_flag=0
M27 22 5 12 VDDO P L=1e-05 W=1e-06 rf_flag=0
M28 22 5 13 VDDO P L=1e-05 W=1e-06 rf_flag=0
M29 23 5 13 VDDO P L=1e-05 W=1e-06 rf_flag=0
M30 23 5 14 VDDO P L=1e-05 W=1e-06 rf_flag=0
M31 24 5 14 VDDO P L=1e-05 W=1e-06 rf_flag=0
M32 24 5 15 VDDO P L=1e-05 W=1e-06 rf_flag=0
M33 7 5 15 VDDO P L=1e-05 W=1e-06 rf_flag=0
M34 8 6 16 VDD P L=1e-05 W=1e-06 rf_flag=0
M35 25 6 16 VDD P L=1e-05 W=1e-06 rf_flag=0
M36 25 6 17 VDD P L=1e-05 W=1e-06 rf_flag=0
M37 26 6 17 VDD P L=1e-05 W=1e-06 rf_flag=0
M38 26 6 18 VDD P L=1e-05 W=1e-06 rf_flag=0
M39 27 6 18 VDD P L=1e-05 W=1e-06 rf_flag=0
M40 27 6 19 VDD P L=1e-05 W=1e-06 rf_flag=0
M41 28 6 19 VDD P L=1e-05 W=1e-06 rf_flag=0
M42 28 6 20 VDD P L=1e-05 W=1e-06 rf_flag=0
M43 30 6 20 VDD P L=1e-05 W=1e-06 rf_flag=0
M44 VDDO 7 VDDO_OK VDDO P L=5e-07 W=1e-06 rf_flag=0
M45 VDD 8 VDD_OK VDD P L=5e-07 W=1e-06 rf_flag=0
M46 VDDO_OK 7 VDDO VDDO P L=5e-07 W=1e-06 rf_flag=0
M47 VDD_OK 8 VDD VDD P L=5e-07 W=1e-06 rf_flag=0
M48 VDDO 7 VDDO_OK VDDO P L=5e-07 W=1e-06 rf_flag=0
M49 VDD 8 VDD_OK VDD P L=5e-07 W=1e-06 rf_flag=0
M50 VDDO_OK 7 VDDO VDDO P L=5e-07 W=1e-06 rf_flag=0
M51 VDD_OK 8 VDD VDD P L=5e-07 W=1e-06 rf_flag=0
M52 VDDO 7 VDDO_OK VDDO P L=5e-07 W=1e-06 rf_flag=0
M53 VDD 8 VDD_OK VDD P L=5e-07 W=1e-06 rf_flag=0
M54 VDDO_OK 7 VDDO VDDO P L=5e-07 W=1e-06 rf_flag=0
M55 VDD_OK 8 VDD VDD P L=5e-07 W=1e-06 rf_flag=0
M56 VDDO 7 VDDO_OK VDDO P L=5e-07 W=1e-06 rf_flag=0
M57 VDD 8 VDD_OK VDD P L=5e-07 W=1e-06 rf_flag=0
M58 VDDO_OK 7 VDDO VDDO P L=5e-07 W=1e-06 rf_flag=0
M59 VDD_OK 8 VDD VDD P L=5e-07 W=1e-06 rf_flag=0
M60 VDDO 7 VDDO_OK VDDO P L=5e-07 W=1e-06 rf_flag=0
M61 VDD 8 VDD_OK VDD P L=5e-07 W=1e-06 rf_flag=0
M62 VDDO_OK 7 VDDO VDDO P L=5e-07 W=1e-06 rf_flag=0
M63 VDD_OK 8 VDD VDD P L=5e-07 W=1e-06 rf_flag=0
M64 VDDO 7 VDDO_OK VDDO P L=5e-07 W=1e-06 rf_flag=0
M65 VDD 8 VDD_OK VDD P L=5e-07 W=1e-06 rf_flag=0
M66 41 5 29 VDDO P L=1e-05 W=1e-06 rf_flag=0
M67 41 5 31 VDDO P L=1e-05 W=1e-06 rf_flag=0
M68 42 5 31 VDDO P L=1e-05 W=1e-06 rf_flag=0
M69 42 5 32 VDDO P L=1e-05 W=1e-06 rf_flag=0
M70 43 5 32 VDDO P L=1e-05 W=1e-06 rf_flag=0
M71 43 5 33 VDDO P L=1e-05 W=1e-06 rf_flag=0
M72 44 5 33 VDDO P L=1e-05 W=1e-06 rf_flag=0
M73 44 5 34 VDDO P L=1e-05 W=1e-06 rf_flag=0
M74 45 5 34 VDDO P L=1e-05 W=1e-06 rf_flag=0
M75 45 5 VDDO VDDO P L=1e-05 W=1e-06 rf_flag=0
M76 46 6 VDD VDD P L=1e-05 W=1e-06 rf_flag=0
M77 46 6 35 VDD P L=1e-05 W=1e-06 rf_flag=0
M78 47 6 35 VDD P L=1e-05 W=1e-06 rf_flag=0
M79 47 6 36 VDD P L=1e-05 W=1e-06 rf_flag=0
M80 48 6 36 VDD P L=1e-05 W=1e-06 rf_flag=0
M81 48 6 37 VDD P L=1e-05 W=1e-06 rf_flag=0
M82 49 6 37 VDD P L=1e-05 W=1e-06 rf_flag=0
M83 49 6 38 VDD P L=1e-05 W=1e-06 rf_flag=0
M84 50 6 38 VDD P L=1e-05 W=1e-06 rf_flag=0
M85 50 6 30 VDD P L=1e-05 W=1e-06 rf_flag=0
M86 VDDO_OK 7 VDDO VDDO P L=5e-07 W=1e-06 rf_flag=0
M87 VDD_OK 8 VDD VDD P L=5e-07 W=1e-06 rf_flag=0
M88 VDDO 7 VDDO_OK VDDO P L=5e-07 W=1e-06 rf_flag=0
M89 VDD 8 VDD_OK VDD P L=5e-07 W=1e-06 rf_flag=0
M90 VDDO_OK 7 VDDO VDDO P L=5e-07 W=1e-06 rf_flag=0
M91 VDD_OK 8 VDD VDD P L=5e-07 W=1e-06 rf_flag=0
M92 VDDO 7 VDDO_OK VDDO P L=5e-07 W=1e-06 rf_flag=0
M93 VDD 8 VDD_OK VDD P L=5e-07 W=1e-06 rf_flag=0
M94 VDDO_OK 7 VDDO VDDO P L=5e-07 W=1e-06 rf_flag=0
M95 VDD_OK 8 VDD VDD P L=5e-07 W=1e-06 rf_flag=0
M96 VDDO 7 VDDO_OK VDDO P L=5e-07 W=1e-06 rf_flag=0
M97 VDD 8 VDD_OK VDD P L=5e-07 W=1e-06 rf_flag=0
M98 VDDO_OK 7 VDDO VDDO P L=5e-07 W=1e-06 rf_flag=0
M99 VDD_OK 8 VDD VDD P L=5e-07 W=1e-06 rf_flag=0
M100 VDDO 7 VDDO_OK VDDO P L=5e-07 W=1e-06 rf_flag=0
M101 VDD 8 VDD_OK VDD P L=5e-07 W=1e-06 rf_flag=0
M102 VDDO_OK 7 VDDO VDDO P L=5e-07 W=1e-06 rf_flag=0
M103 VDD_OK 8 VDD VDD P L=5e-07 W=1e-06 rf_flag=0
R104 5 VSSO 1127.2 L=5e-06 W=2e-06 postlayout=1 $SUB=VSSO $[RE3]
R105 6 VSS 1127.2 L=5e-06 W=2e-06 postlayout=1 $SUB=VSS $[RE3]
R106 VDD 9 1127.2 L=5e-06 W=2e-06 postlayout=1 $SUB=VSSO $[RE3]
R107 VDDO 10 1127.2 L=5e-06 W=2e-06 postlayout=1 $SUB=VSS $[RE3]
D108 VSS VDDO dwn2psub AREA=9.15257e-10 PJ=0.00021382
D109 VSS VDD dwn2psub AREA=9.15257e-10 PJ=0.00021382
D110 VSSO VDDO dwn2psub AREA=9.15257e-10 PJ=0.00021382
D111 VSS VDD dwn2psub AREA=9.15257e-10 PJ=0.00021382
.ENDS

.SUBCKT POK_50_18 VDDO VSSO VSS VDD VDDO_OK VDD_OK
*.PININFO VDDO:B VSSO:B VSS:B VDD:B VDDO_OK:O VDD_OK:O
M0 VDDO_OK 7 VSSO VSSO N5 L=6e-07 W=1.5e-06 rf_flag=0
M1 VSSO 7 VDDO_OK VSSO N5 L=6e-07 W=1.5e-06 rf_flag=0
M2 VDDO_OK 7 VSSO VSSO N5 L=6e-07 W=1.5e-06 rf_flag=0
M3 VSSO 7 VDDO_OK VSSO N5 L=6e-07 W=1.5e-06 rf_flag=0
M4 VDDO_OK 7 VSSO VSSO N5 L=6e-07 W=1.5e-06 rf_flag=0
M5 VSSO 7 VDDO_OK VSSO N5 L=6e-07 W=1.5e-06 rf_flag=0
M6 VDDO_OK 7 VSSO VSSO N5 L=6e-07 W=1.5e-06 rf_flag=0
M7 VSSO 7 VDDO_OK VSSO N5 L=6e-07 W=1.5e-06 rf_flag=0
M8 VDDO_OK 7 VSSO VSSO N5 L=6e-07 W=1.5e-06 rf_flag=0
M9 VSSO 7 VDDO_OK VSSO N5 L=6e-07 W=1.5e-06 rf_flag=0
M10 7 9 VSSO VSSO N5 L=6e-07 W=5e-06 rf_flag=0
M11 8 10 VSS VSS N5 L=6e-07 W=5e-06 rf_flag=0
M12 VSSO 9 7 VSSO N5 L=6e-07 W=5e-06 rf_flag=0
M13 VSS 10 8 VSS N5 L=6e-07 W=5e-06 rf_flag=0
M14 VDD_OK 8 VSS VSS N L=6e-07 W=1.5e-06 rf_flag=0
M15 VSS 8 VDD_OK VSS N L=6e-07 W=1.5e-06 rf_flag=0
M16 VDD_OK 8 VSS VSS N L=6e-07 W=1.5e-06 rf_flag=0
M17 VSS 8 VDD_OK VSS N L=6e-07 W=1.5e-06 rf_flag=0
M18 VDD_OK 8 VSS VSS N L=6e-07 W=1.5e-06 rf_flag=0
M19 VSS 8 VDD_OK VSS N L=6e-07 W=1.5e-06 rf_flag=0
M20 VDD_OK 8 VSS VSS N L=6e-07 W=1.5e-06 rf_flag=0
M21 VSS 8 VDD_OK VSS N L=6e-07 W=1.5e-06 rf_flag=0
M22 VDD_OK 8 VSS VSS N L=6e-07 W=1.5e-06 rf_flag=0
M23 VSS 8 VDD_OK VSS N L=6e-07 W=1.5e-06 rf_flag=0
M24 29 5 11 VDDO P5 L=1e-05 W=1e-06 rf_flag=0
M25 21 5 11 VDDO P5 L=1e-05 W=1e-06 rf_flag=0
M26 21 5 12 VDDO P5 L=1e-05 W=1e-06 rf_flag=0
M27 22 5 12 VDDO P5 L=1e-05 W=1e-06 rf_flag=0
M28 22 5 13 VDDO P5 L=1e-05 W=1e-06 rf_flag=0
M29 23 5 13 VDDO P5 L=1e-05 W=1e-06 rf_flag=0
M30 23 5 14 VDDO P5 L=1e-05 W=1e-06 rf_flag=0
M31 24 5 14 VDDO P5 L=1e-05 W=1e-06 rf_flag=0
M32 24 5 15 VDDO P5 L=1e-05 W=1e-06 rf_flag=0
M33 7 5 15 VDDO P5 L=1e-05 W=1e-06 rf_flag=0
M34 VDDO 7 VDDO_OK VDDO P5 L=5e-07 W=1e-06 rf_flag=0
M35 VDDO_OK 7 VDDO VDDO P5 L=5e-07 W=1e-06 rf_flag=0
M36 VDDO 7 VDDO_OK VDDO P5 L=5e-07 W=1e-06 rf_flag=0
M37 VDDO_OK 7 VDDO VDDO P5 L=5e-07 W=1e-06 rf_flag=0
M38 VDDO 7 VDDO_OK VDDO P5 L=5e-07 W=1e-06 rf_flag=0
M39 VDDO_OK 7 VDDO VDDO P5 L=5e-07 W=1e-06 rf_flag=0
M40 VDDO 7 VDDO_OK VDDO P5 L=5e-07 W=1e-06 rf_flag=0
M41 VDDO_OK 7 VDDO VDDO P5 L=5e-07 W=1e-06 rf_flag=0
M42 VDDO 7 VDDO_OK VDDO P5 L=5e-07 W=1e-06 rf_flag=0
M43 VDDO_OK 7 VDDO VDDO P5 L=5e-07 W=1e-06 rf_flag=0
M44 VDDO 7 VDDO_OK VDDO P5 L=5e-07 W=1e-06 rf_flag=0
M45 41 5 29 VDDO P5 L=1e-05 W=1e-06 rf_flag=0
M46 41 5 31 VDDO P5 L=1e-05 W=1e-06 rf_flag=0
M47 42 5 31 VDDO P5 L=1e-05 W=1e-06 rf_flag=0
M48 42 5 32 VDDO P5 L=1e-05 W=1e-06 rf_flag=0
M49 43 5 32 VDDO P5 L=1e-05 W=1e-06 rf_flag=0
M50 43 5 33 VDDO P5 L=1e-05 W=1e-06 rf_flag=0
M51 44 5 33 VDDO P5 L=1e-05 W=1e-06 rf_flag=0
M52 44 5 34 VDDO P5 L=1e-05 W=1e-06 rf_flag=0
M53 45 5 34 VDDO P5 L=1e-05 W=1e-06 rf_flag=0
M54 45 5 VDDO VDDO P5 L=1e-05 W=1e-06 rf_flag=0
M55 VDDO_OK 7 VDDO VDDO P5 L=5e-07 W=1e-06 rf_flag=0
M56 VDDO 7 VDDO_OK VDDO P5 L=5e-07 W=1e-06 rf_flag=0
M57 VDDO_OK 7 VDDO VDDO P5 L=5e-07 W=1e-06 rf_flag=0
M58 VDDO 7 VDDO_OK VDDO P5 L=5e-07 W=1e-06 rf_flag=0
M59 VDDO_OK 7 VDDO VDDO P5 L=5e-07 W=1e-06 rf_flag=0
M60 VDDO 7 VDDO_OK VDDO P5 L=5e-07 W=1e-06 rf_flag=0
M61 VDDO_OK 7 VDDO VDDO P5 L=5e-07 W=1e-06 rf_flag=0
M62 VDDO 7 VDDO_OK VDDO P5 L=5e-07 W=1e-06 rf_flag=0
M63 VDDO_OK 7 VDDO VDDO P5 L=5e-07 W=1e-06 rf_flag=0
M64 8 6 16 VDD P L=1e-05 W=1e-06 rf_flag=0
M65 25 6 16 VDD P L=1e-05 W=1e-06 rf_flag=0
M66 25 6 17 VDD P L=1e-05 W=1e-06 rf_flag=0
M67 26 6 17 VDD P L=1e-05 W=1e-06 rf_flag=0
M68 26 6 18 VDD P L=1e-05 W=1e-06 rf_flag=0
M69 27 6 18 VDD P L=1e-05 W=1e-06 rf_flag=0
M70 27 6 19 VDD P L=1e-05 W=1e-06 rf_flag=0
M71 28 6 19 VDD P L=1e-05 W=1e-06 rf_flag=0
M72 28 6 20 VDD P L=1e-05 W=1e-06 rf_flag=0
M73 30 6 20 VDD P L=1e-05 W=1e-06 rf_flag=0
M74 VDD 8 VDD_OK VDD P L=5e-07 W=1e-06 rf_flag=0
M75 VDD_OK 8 VDD VDD P L=5e-07 W=1e-06 rf_flag=0
M76 VDD 8 VDD_OK VDD P L=5e-07 W=1e-06 rf_flag=0
M77 VDD_OK 8 VDD VDD P L=5e-07 W=1e-06 rf_flag=0
M78 VDD 8 VDD_OK VDD P L=5e-07 W=1e-06 rf_flag=0
M79 VDD_OK 8 VDD VDD P L=5e-07 W=1e-06 rf_flag=0
M80 VDD 8 VDD_OK VDD P L=5e-07 W=1e-06 rf_flag=0
M81 VDD_OK 8 VDD VDD P L=5e-07 W=1e-06 rf_flag=0
M82 VDD 8 VDD_OK VDD P L=5e-07 W=1e-06 rf_flag=0
M83 VDD_OK 8 VDD VDD P L=5e-07 W=1e-06 rf_flag=0
M84 VDD 8 VDD_OK VDD P L=5e-07 W=1e-06 rf_flag=0
M85 46 6 VDD VDD P L=1e-05 W=1e-06 rf_flag=0
M86 46 6 35 VDD P L=1e-05 W=1e-06 rf_flag=0
M87 47 6 35 VDD P L=1e-05 W=1e-06 rf_flag=0
M88 47 6 36 VDD P L=1e-05 W=1e-06 rf_flag=0
M89 48 6 36 VDD P L=1e-05 W=1e-06 rf_flag=0
M90 48 6 37 VDD P L=1e-05 W=1e-06 rf_flag=0
M91 49 6 37 VDD P L=1e-05 W=1e-06 rf_flag=0
M92 49 6 38 VDD P L=1e-05 W=1e-06 rf_flag=0
M93 50 6 38 VDD P L=1e-05 W=1e-06 rf_flag=0
M94 50 6 30 VDD P L=1e-05 W=1e-06 rf_flag=0
M95 VDD_OK 8 VDD VDD P L=5e-07 W=1e-06 rf_flag=0
M96 VDD 8 VDD_OK VDD P L=5e-07 W=1e-06 rf_flag=0
M97 VDD_OK 8 VDD VDD P L=5e-07 W=1e-06 rf_flag=0
M98 VDD 8 VDD_OK VDD P L=5e-07 W=1e-06 rf_flag=0
M99 VDD_OK 8 VDD VDD P L=5e-07 W=1e-06 rf_flag=0
M100 VDD 8 VDD_OK VDD P L=5e-07 W=1e-06 rf_flag=0
M101 VDD_OK 8 VDD VDD P L=5e-07 W=1e-06 rf_flag=0
M102 VDD 8 VDD_OK VDD P L=5e-07 W=1e-06 rf_flag=0
M103 VDD_OK 8 VDD VDD P L=5e-07 W=1e-06 rf_flag=0
R104 5 VSSO 1127.2 L=5e-06 W=2e-06 postlayout=1 $SUB=VSSO $[RE3]
R105 6 VSS 1127.2 L=5e-06 W=2e-06 postlayout=1 $SUB=VSS $[RE3]
R106 VDD 9 1127.2 L=5e-06 W=2e-06 postlayout=1 $SUB=VSSO $[RE3]
R107 VDDO 10 1127.2 L=5e-06 W=2e-06 postlayout=1 $SUB=VSS $[RE3]
D108 VSS VDDO dwn2psub AREA=9.15257e-10 PJ=0.00021382
D109 VSS VDD dwn2psub AREA=9.15257e-10 PJ=0.00021382
D110 VSSO VDDO dwn2psub AREA=9.15257e-10 PJ=0.00021382
D111 VSS VDD dwn2psub AREA=9.15257e-10 PJ=0.00021382
.ENDS

.SUBCKT POK_50_50 VDDO VSSO VSS VDD VDDO_OK VDD_OK
*.PININFO VDDO:B VSSO:B VSS:B VDD:B VDDO_OK:O VDD_OK:O
M0 VDDO_OK 7 VSSO VSSO N5 L=6e-07 W=1.5e-06 rf_flag=0
M1 VDD_OK 8 VSS VSS N5 L=6e-07 W=1.5e-06 rf_flag=0
M2 VSSO 7 VDDO_OK VSSO N5 L=6e-07 W=1.5e-06 rf_flag=0
M3 VSS 8 VDD_OK VSS N5 L=6e-07 W=1.5e-06 rf_flag=0
M4 VDDO_OK 7 VSSO VSSO N5 L=6e-07 W=1.5e-06 rf_flag=0
M5 VDD_OK 8 VSS VSS N5 L=6e-07 W=1.5e-06 rf_flag=0
M6 VSSO 7 VDDO_OK VSSO N5 L=6e-07 W=1.5e-06 rf_flag=0
M7 VSS 8 VDD_OK VSS N5 L=6e-07 W=1.5e-06 rf_flag=0
M8 VDDO_OK 7 VSSO VSSO N5 L=6e-07 W=1.5e-06 rf_flag=0
M9 VDD_OK 8 VSS VSS N5 L=6e-07 W=1.5e-06 rf_flag=0
M10 VSSO 7 VDDO_OK VSSO N5 L=6e-07 W=1.5e-06 rf_flag=0
M11 VSS 8 VDD_OK VSS N5 L=6e-07 W=1.5e-06 rf_flag=0
M12 VDDO_OK 7 VSSO VSSO N5 L=6e-07 W=1.5e-06 rf_flag=0
M13 VDD_OK 8 VSS VSS N5 L=6e-07 W=1.5e-06 rf_flag=0
M14 VSSO 7 VDDO_OK VSSO N5 L=6e-07 W=1.5e-06 rf_flag=0
M15 VSS 8 VDD_OK VSS N5 L=6e-07 W=1.5e-06 rf_flag=0
M16 VDDO_OK 7 VSSO VSSO N5 L=6e-07 W=1.5e-06 rf_flag=0
M17 VDD_OK 8 VSS VSS N5 L=6e-07 W=1.5e-06 rf_flag=0
M18 VSSO 7 VDDO_OK VSSO N5 L=6e-07 W=1.5e-06 rf_flag=0
M19 VSS 8 VDD_OK VSS N5 L=6e-07 W=1.5e-06 rf_flag=0
M20 7 9 VSSO VSSO N5 L=6e-07 W=5e-06 rf_flag=0
M21 8 10 VSS VSS N5 L=6e-07 W=5e-06 rf_flag=0
M22 VSSO 9 7 VSSO N5 L=6e-07 W=5e-06 rf_flag=0
M23 VSS 10 8 VSS N5 L=6e-07 W=5e-06 rf_flag=0
M24 29 5 11 VDDO P5 L=1e-05 W=1e-06 rf_flag=0
M25 21 5 11 VDDO P5 L=1e-05 W=1e-06 rf_flag=0
M26 21 5 12 VDDO P5 L=1e-05 W=1e-06 rf_flag=0
M27 22 5 12 VDDO P5 L=1e-05 W=1e-06 rf_flag=0
M28 22 5 13 VDDO P5 L=1e-05 W=1e-06 rf_flag=0
M29 23 5 13 VDDO P5 L=1e-05 W=1e-06 rf_flag=0
M30 23 5 14 VDDO P5 L=1e-05 W=1e-06 rf_flag=0
M31 24 5 14 VDDO P5 L=1e-05 W=1e-06 rf_flag=0
M32 24 5 15 VDDO P5 L=1e-05 W=1e-06 rf_flag=0
M33 7 5 15 VDDO P5 L=1e-05 W=1e-06 rf_flag=0
M34 8 6 16 VDD P5 L=1e-05 W=1e-06 rf_flag=0
M35 25 6 16 VDD P5 L=1e-05 W=1e-06 rf_flag=0
M36 25 6 17 VDD P5 L=1e-05 W=1e-06 rf_flag=0
M37 26 6 17 VDD P5 L=1e-05 W=1e-06 rf_flag=0
M38 26 6 18 VDD P5 L=1e-05 W=1e-06 rf_flag=0
M39 27 6 18 VDD P5 L=1e-05 W=1e-06 rf_flag=0
M40 27 6 19 VDD P5 L=1e-05 W=1e-06 rf_flag=0
M41 28 6 19 VDD P5 L=1e-05 W=1e-06 rf_flag=0
M42 28 6 20 VDD P5 L=1e-05 W=1e-06 rf_flag=0
M43 30 6 20 VDD P5 L=1e-05 W=1e-06 rf_flag=0
M44 VDDO 7 VDDO_OK VDDO P5 L=5e-07 W=1e-06 rf_flag=0
M45 VDD 8 VDD_OK VDD P5 L=5e-07 W=1e-06 rf_flag=0
M46 VDDO_OK 7 VDDO VDDO P5 L=5e-07 W=1e-06 rf_flag=0
M47 VDD_OK 8 VDD VDD P5 L=5e-07 W=1e-06 rf_flag=0
M48 VDDO 7 VDDO_OK VDDO P5 L=5e-07 W=1e-06 rf_flag=0
M49 VDD 8 VDD_OK VDD P5 L=5e-07 W=1e-06 rf_flag=0
M50 VDDO_OK 7 VDDO VDDO P5 L=5e-07 W=1e-06 rf_flag=0
M51 VDD_OK 8 VDD VDD P5 L=5e-07 W=1e-06 rf_flag=0
M52 VDDO 7 VDDO_OK VDDO P5 L=5e-07 W=1e-06 rf_flag=0
M53 VDD 8 VDD_OK VDD P5 L=5e-07 W=1e-06 rf_flag=0
M54 VDDO_OK 7 VDDO VDDO P5 L=5e-07 W=1e-06 rf_flag=0
M55 VDD_OK 8 VDD VDD P5 L=5e-07 W=1e-06 rf_flag=0
M56 VDDO 7 VDDO_OK VDDO P5 L=5e-07 W=1e-06 rf_flag=0
M57 VDD 8 VDD_OK VDD P5 L=5e-07 W=1e-06 rf_flag=0
M58 VDDO_OK 7 VDDO VDDO P5 L=5e-07 W=1e-06 rf_flag=0
M59 VDD_OK 8 VDD VDD P5 L=5e-07 W=1e-06 rf_flag=0
M60 VDDO 7 VDDO_OK VDDO P5 L=5e-07 W=1e-06 rf_flag=0
M61 VDD 8 VDD_OK VDD P5 L=5e-07 W=1e-06 rf_flag=0
M62 VDDO_OK 7 VDDO VDDO P5 L=5e-07 W=1e-06 rf_flag=0
M63 VDD_OK 8 VDD VDD P5 L=5e-07 W=1e-06 rf_flag=0
M64 VDDO 7 VDDO_OK VDDO P5 L=5e-07 W=1e-06 rf_flag=0
M65 VDD 8 VDD_OK VDD P5 L=5e-07 W=1e-06 rf_flag=0
M66 41 5 29 VDDO P5 L=1e-05 W=1e-06 rf_flag=0
M67 41 5 31 VDDO P5 L=1e-05 W=1e-06 rf_flag=0
M68 42 5 31 VDDO P5 L=1e-05 W=1e-06 rf_flag=0
M69 42 5 32 VDDO P5 L=1e-05 W=1e-06 rf_flag=0
M70 43 5 32 VDDO P5 L=1e-05 W=1e-06 rf_flag=0
M71 43 5 33 VDDO P5 L=1e-05 W=1e-06 rf_flag=0
M72 44 5 33 VDDO P5 L=1e-05 W=1e-06 rf_flag=0
M73 44 5 34 VDDO P5 L=1e-05 W=1e-06 rf_flag=0
M74 45 5 34 VDDO P5 L=1e-05 W=1e-06 rf_flag=0
M75 45 5 VDDO VDDO P5 L=1e-05 W=1e-06 rf_flag=0
M76 46 6 VDD VDD P5 L=1e-05 W=1e-06 rf_flag=0
M77 46 6 35 VDD P5 L=1e-05 W=1e-06 rf_flag=0
M78 47 6 35 VDD P5 L=1e-05 W=1e-06 rf_flag=0
M79 47 6 36 VDD P5 L=1e-05 W=1e-06 rf_flag=0
M80 48 6 36 VDD P5 L=1e-05 W=1e-06 rf_flag=0
M81 48 6 37 VDD P5 L=1e-05 W=1e-06 rf_flag=0
M82 49 6 37 VDD P5 L=1e-05 W=1e-06 rf_flag=0
M83 49 6 38 VDD P5 L=1e-05 W=1e-06 rf_flag=0
M84 50 6 38 VDD P5 L=1e-05 W=1e-06 rf_flag=0
M85 50 6 30 VDD P5 L=1e-05 W=1e-06 rf_flag=0
M86 VDDO_OK 7 VDDO VDDO P5 L=5e-07 W=1e-06 rf_flag=0
M87 VDD_OK 8 VDD VDD P5 L=5e-07 W=1e-06 rf_flag=0
M88 VDDO 7 VDDO_OK VDDO P5 L=5e-07 W=1e-06 rf_flag=0
M89 VDD 8 VDD_OK VDD P5 L=5e-07 W=1e-06 rf_flag=0
M90 VDDO_OK 7 VDDO VDDO P5 L=5e-07 W=1e-06 rf_flag=0
M91 VDD_OK 8 VDD VDD P5 L=5e-07 W=1e-06 rf_flag=0
M92 VDDO 7 VDDO_OK VDDO P5 L=5e-07 W=1e-06 rf_flag=0
M93 VDD 8 VDD_OK VDD P5 L=5e-07 W=1e-06 rf_flag=0
M94 VDDO_OK 7 VDDO VDDO P5 L=5e-07 W=1e-06 rf_flag=0
M95 VDD_OK 8 VDD VDD P5 L=5e-07 W=1e-06 rf_flag=0
M96 VDDO 7 VDDO_OK VDDO P5 L=5e-07 W=1e-06 rf_flag=0
M97 VDD 8 VDD_OK VDD P5 L=5e-07 W=1e-06 rf_flag=0
M98 VDDO_OK 7 VDDO VDDO P5 L=5e-07 W=1e-06 rf_flag=0
M99 VDD_OK 8 VDD VDD P5 L=5e-07 W=1e-06 rf_flag=0
M100 VDDO 7 VDDO_OK VDDO P5 L=5e-07 W=1e-06 rf_flag=0
M101 VDD 8 VDD_OK VDD P5 L=5e-07 W=1e-06 rf_flag=0
M102 VDDO_OK 7 VDDO VDDO P5 L=5e-07 W=1e-06 rf_flag=0
M103 VDD_OK 8 VDD VDD P5 L=5e-07 W=1e-06 rf_flag=0
R104 5 VSSO 1127.2 L=5e-06 W=2e-06 postlayout=1 $SUB=VSSO $[RE3]
R105 6 VSS 1127.2 L=5e-06 W=2e-06 postlayout=1 $SUB=VSS $[RE3]
R106 VDD 9 1127.2 L=5e-06 W=2e-06 postlayout=1 $SUB=VSSO $[RE3]
R107 VDDO 10 1127.2 L=5e-06 W=2e-06 postlayout=1 $SUB=VSS $[RE3]
D108 VSS VDDO dwn2psub AREA=9.15257e-10 PJ=0.00021382
D109 VSS VDD dwn2psub AREA=9.15257e-10 PJ=0.00021382
D110 VSSO VDDO dwn2psub AREA=9.15257e-10 PJ=0.00021382
D111 VSS VDD dwn2psub AREA=9.15257e-10 PJ=0.00021382
.ENDS

.SUBCKT PV0A_18_18 VSSO VDDO VSS VDD
*.PININFO VSSO:B VDDO:B VSS:B VDD:B
M0 7 VDDO 7 VSSO N L=4.55e-06 W=5.5e-06 rf_flag=0
M1 7 VDDO 7 VSSO N L=4.55e-06 W=5.5e-06 rf_flag=0
M2 7 VDDO 7 VSSO N L=4.55e-06 W=5.5e-06 rf_flag=0
M3 7 VDDO 7 VSSO N L=4.55e-06 W=5.5e-06 rf_flag=0
M4 7 VDDO 7 VSSO N L=4.55e-06 W=5.5e-06 rf_flag=0
M5 7 VDDO 7 VSSO N L=4.55e-06 W=5.5e-06 rf_flag=0
M6 7 VDDO 7 VSSO N L=4.55e-06 W=5.5e-06 rf_flag=0
M7 7 VDDO 7 VSSO N L=4.55e-06 W=5.5e-06 rf_flag=0
M8 7 VDDO 7 VSSO N L=4.55e-06 W=5.5e-06 rf_flag=0
M9 7 VDDO 7 VSSO N L=4.55e-06 W=5.5e-06 rf_flag=0
M10 8 VDD 8 VSSO N L=4.55e-06 W=5.5e-06 rf_flag=0
M11 8 VDD 8 VSSO N L=4.55e-06 W=5.5e-06 rf_flag=0
M12 8 VDD 8 VSSO N L=4.55e-06 W=5.5e-06 rf_flag=0
M13 8 VDD 8 VSSO N L=4.55e-06 W=5.5e-06 rf_flag=0
M14 8 VDD 8 VSSO N L=4.55e-06 W=5.5e-06 rf_flag=0
M15 8 VDD 8 VSSO N L=4.55e-06 W=5.5e-06 rf_flag=0
M16 8 VDD 8 VSSO N L=4.55e-06 W=5.5e-06 rf_flag=0
M17 8 VDD 8 VSSO N L=4.55e-06 W=5.5e-06 rf_flag=0
M18 8 VDD 8 VSSO N L=4.55e-06 W=5.5e-06 rf_flag=0
M19 8 VDD 8 VSSO N L=4.55e-06 W=5.5e-06 rf_flag=0
R20 5 VSSO 8325.14 L=4e-05 W=2e-06 postlayout=1 $SUB=VSSO $[RE3]
R21 VSSO 6 8325.14 L=4e-05 W=2e-06 postlayout=1 $SUB=VSSO $[RE3]
R22 5 7 8325.14 L=4e-05 W=2e-06 postlayout=1 $SUB=VSSO $[RE3]
R23 8 6 8325.14 L=4e-05 W=2e-06 postlayout=1 $SUB=VSSO $[RE3]
D24 VSS VDDO dwn2psub AREA=8.1276e-10 PJ=0.00080876
D25 VSS VDD dwn2psub AREA=8.1276e-10 PJ=0.00080876
D26 VSSO VDDO dwn2psub AREA=8.1276e-10 PJ=0.00080876
D27 VSSO VDD dwn2psub AREA=8.1276e-10 PJ=0.00080876
D28 VSSO VDDO dwn2psub AREA=8.1276e-10 PJ=0.00080876
D29 VSSO VDD dwn2psub AREA=8.1276e-10 PJ=0.00080876
D30 VSS VDDO dwn2psub AREA=2.7424e-10 PJ=0.00027424
D31 VSS VDDO dwn2psub AREA=2.7392e-10 PJ=0.00027392
D32 VSSO VDDO dwn2psub AREA=2.7424e-10 PJ=0.00027424
D33 VSSO VDDO dwn2psub AREA=2.7392e-10 PJ=0.00027392
D34 VSSO VSSO dwn2psub AREA=6.3709e-10 PJ=0.00010544
D35 VSSO VSS dwn2psub AREA=6.3709e-10 PJ=0.00010544
M36 VDDO 7 VSSO VSSO n18pcesd L=2.5e-07 W=2.5e-05
M37 VSSO 7 VDDO VSSO n18pcesd L=2.5e-07 W=2.5e-05
M38 VDDO 7 VSSO VSSO n18pcesd L=2.5e-07 W=2.5e-05
M39 VSSO 7 VDDO VSSO n18pcesd L=2.5e-07 W=2.5e-05
M40 VDDO 7 VSSO VSSO n18pcesd L=2.5e-07 W=2.5e-05
M41 VSSO 7 VDDO VSSO n18pcesd L=2.5e-07 W=2.5e-05
M42 VDDO 7 VSSO VSSO n18pcesd L=2.5e-07 W=2.5e-05
M43 VSSO 7 VDDO VSSO n18pcesd L=2.5e-07 W=2.5e-05
M44 VDDO 7 VSSO VSSO n18pcesd L=2.5e-07 W=2.5e-05
M45 VSSO 7 VDDO VSSO n18pcesd L=2.5e-07 W=2.5e-05
M46 VDDO 7 VSSO VSSO n18pcesd L=2.5e-07 W=2.5e-05
M47 VSSO 7 VDDO VSSO n18pcesd L=2.5e-07 W=2.5e-05
M48 VDDO 7 VSSO VSSO n18pcesd L=2.5e-07 W=2.5e-05
M49 VSSO 7 VDDO VSSO n18pcesd L=2.5e-07 W=2.5e-05
M50 VDDO 7 VSSO VSSO n18pcesd L=2.5e-07 W=2.5e-05
M51 VSSO 7 VDDO VSSO n18pcesd L=2.5e-07 W=2.5e-05
M52 VDDO 7 VSSO VSSO n18pcesd L=2.5e-07 W=2.5e-05
M53 VSSO 7 VDDO VSSO n18pcesd L=2.5e-07 W=2.5e-05
M54 VDDO 7 VSSO VSSO n18pcesd L=2.5e-07 W=2.5e-05
M55 VSSO 7 VDDO VSSO n18pcesd L=2.5e-07 W=2.5e-05
M56 VDD 8 VSSO VSSO n18pcesd L=2.5e-07 W=2.5e-05
M57 VSSO 8 VDD VSSO n18pcesd L=2.5e-07 W=2.5e-05
M58 VDD 8 VSSO VSSO n18pcesd L=2.5e-07 W=2.5e-05
M59 VSSO 8 VDD VSSO n18pcesd L=2.5e-07 W=2.5e-05
M60 VDD 8 VSSO VSSO n18pcesd L=2.5e-07 W=2.5e-05
M61 VSSO 8 VDD VSSO n18pcesd L=2.5e-07 W=2.5e-05
M62 VDD 8 VSSO VSSO n18pcesd L=2.5e-07 W=2.5e-05
M63 VSSO 8 VDD VSSO n18pcesd L=2.5e-07 W=2.5e-05
M64 VDD 8 VSSO VSSO n18pcesd L=2.5e-07 W=2.5e-05
M65 VSSO 8 VDD VSSO n18pcesd L=2.5e-07 W=2.5e-05
M66 VDD 8 VSSO VSSO n18pcesd L=2.5e-07 W=2.5e-05
M67 VSSO 8 VDD VSSO n18pcesd L=2.5e-07 W=2.5e-05
M68 VDD 8 VSSO VSSO n18pcesd L=2.5e-07 W=2.5e-05
M69 VSSO 8 VDD VSSO n18pcesd L=2.5e-07 W=2.5e-05
M70 VDD 8 VSSO VSSO n18pcesd L=2.5e-07 W=2.5e-05
M71 VSSO 8 VDD VSSO n18pcesd L=2.5e-07 W=2.5e-05
M72 VDD 8 VSSO VSSO n18pcesd L=2.5e-07 W=2.5e-05
M73 VSSO 8 VDD VSSO n18pcesd L=2.5e-07 W=2.5e-05
M74 VDD 8 VSSO VSSO n18pcesd L=2.5e-07 W=2.5e-05
M75 VSSO 8 VDD VSSO n18pcesd L=2.5e-07 W=2.5e-05
D76 VSS VSSO dpnwcpl18 AREA=2.242e-11 PJ=3.25314e-05 nf=1
D77 VSS VSSO dpnwcpl18 AREA=2.242e-11 PJ=3.25314e-05 nf=1
D78 VSS VSSO dpnwcpl18 AREA=2.242e-11 PJ=3.25314e-05 nf=1
D79 VSS VSSO dpnwcpl18 AREA=2.242e-11 PJ=3.25314e-05 nf=1
D80 VSS VSSO dpnwcpl18 AREA=2.242e-11 PJ=3.25314e-05 nf=1
D81 VSS VSSO dpnwcpl18 AREA=2.242e-11 PJ=3.25314e-05 nf=1
D82 VSS VSSO dpnwcpl18 AREA=2.242e-11 PJ=3.25314e-05 nf=1
D83 VSSO VSS dpnwcpl18 AREA=2.242e-11 PJ=3.25314e-05 nf=1
D84 VSSO VSS dpnwcpl18 AREA=2.242e-11 PJ=3.25314e-05 nf=1
D85 VSSO VSS dpnwcpl18 AREA=2.242e-11 PJ=3.25314e-05 nf=1
D86 VSSO VSS dpnwcpl18 AREA=2.242e-11 PJ=3.25314e-05 nf=1
D87 VSSO VSS dpnwcpl18 AREA=2.242e-11 PJ=3.25314e-05 nf=1
D88 VSSO VSS dpnwcpl18 AREA=2.242e-11 PJ=3.25314e-05 nf=1
D89 VSSO VSS dpnwcpl18 AREA=2.242e-11 PJ=3.25314e-05 nf=1
.ENDS

.SUBCKT PV0A_50_18 VSSO VDDO VSS VDD
*.PININFO VSSO:B VDDO:B VSS:B VDD:B
M0 7 VDDO 7 VSSO N5 L=4.55e-06 W=5.5e-06 rf_flag=0
M1 7 VDDO 7 VSSO N5 L=4.55e-06 W=5.5e-06 rf_flag=0
M2 7 VDDO 7 VSSO N5 L=4.55e-06 W=5.5e-06 rf_flag=0
M3 7 VDDO 7 VSSO N5 L=4.55e-06 W=5.5e-06 rf_flag=0
M4 7 VDDO 7 VSSO N5 L=4.55e-06 W=5.5e-06 rf_flag=0
M5 7 VDDO 7 VSSO N5 L=4.55e-06 W=5.5e-06 rf_flag=0
M6 7 VDDO 7 VSSO N5 L=4.55e-06 W=5.5e-06 rf_flag=0
M7 7 VDDO 7 VSSO N5 L=4.55e-06 W=5.5e-06 rf_flag=0
M8 7 VDDO 7 VSSO N5 L=4.55e-06 W=5.5e-06 rf_flag=0
M9 7 VDDO 7 VSSO N5 L=4.55e-06 W=5.5e-06 rf_flag=0
M10 8 VDD 8 VSSO N L=4.55e-06 W=5.5e-06 rf_flag=0
M11 8 VDD 8 VSSO N L=4.55e-06 W=5.5e-06 rf_flag=0
M12 8 VDD 8 VSSO N L=4.55e-06 W=5.5e-06 rf_flag=0
M13 8 VDD 8 VSSO N L=4.55e-06 W=5.5e-06 rf_flag=0
M14 8 VDD 8 VSSO N L=4.55e-06 W=5.5e-06 rf_flag=0
M15 8 VDD 8 VSSO N L=4.55e-06 W=5.5e-06 rf_flag=0
M16 8 VDD 8 VSSO N L=4.55e-06 W=5.5e-06 rf_flag=0
M17 8 VDD 8 VSSO N L=4.55e-06 W=5.5e-06 rf_flag=0
M18 8 VDD 8 VSSO N L=4.55e-06 W=5.5e-06 rf_flag=0
M19 8 VDD 8 VSSO N L=4.55e-06 W=5.5e-06 rf_flag=0
R20 5 VSSO 8325.14 L=4e-05 W=2e-06 postlayout=1 $SUB=VSSO $[RE3]
R21 VSSO 6 8325.14 L=4e-05 W=2e-06 postlayout=1 $SUB=VSSO $[RE3]
R22 5 7 8325.14 L=4e-05 W=2e-06 postlayout=1 $SUB=VSSO $[RE3]
R23 8 6 8325.14 L=4e-05 W=2e-06 postlayout=1 $SUB=VSSO $[RE3]
D24 VSS VDDO dwn2psub AREA=8.1276e-10 PJ=0.00080876
D25 VSS VDD dwn2psub AREA=8.1276e-10 PJ=0.00080876
D26 VSSO VDDO dwn2psub AREA=8.1276e-10 PJ=0.00080876
D27 VSSO VDD dwn2psub AREA=8.1276e-10 PJ=0.00080876
D28 VSSO VDDO dwn2psub AREA=8.1276e-10 PJ=0.00080876
D29 VSSO VDD dwn2psub AREA=8.1276e-10 PJ=0.00080876
D30 VSS VDDO dwn2psub AREA=2.7424e-10 PJ=0.00027424
D31 VSS VDDO dwn2psub AREA=2.7392e-10 PJ=0.00027392
D32 VSSO VDDO dwn2psub AREA=2.7424e-10 PJ=0.00027424
D33 VSSO VDDO dwn2psub AREA=2.7392e-10 PJ=0.00027392
D34 VSSO VSSO dwn2psub AREA=6.3709e-10 PJ=0.00010544
D35 VSSO VSS dwn2psub AREA=6.3709e-10 PJ=0.00010544
M36 VDD 8 VSSO VSSO n18pcesd L=2.5e-07 W=2.5e-05
M37 VSSO 8 VDD VSSO n18pcesd L=2.5e-07 W=2.5e-05
M38 VDD 8 VSSO VSSO n18pcesd L=2.5e-07 W=2.5e-05
M39 VSSO 8 VDD VSSO n18pcesd L=2.5e-07 W=2.5e-05
M40 VDD 8 VSSO VSSO n18pcesd L=2.5e-07 W=2.5e-05
M41 VSSO 8 VDD VSSO n18pcesd L=2.5e-07 W=2.5e-05
M42 VDD 8 VSSO VSSO n18pcesd L=2.5e-07 W=2.5e-05
M43 VSSO 8 VDD VSSO n18pcesd L=2.5e-07 W=2.5e-05
M44 VDD 8 VSSO VSSO n18pcesd L=2.5e-07 W=2.5e-05
M45 VSSO 8 VDD VSSO n18pcesd L=2.5e-07 W=2.5e-05
M46 VDD 8 VSSO VSSO n18pcesd L=2.5e-07 W=2.5e-05
M47 VSSO 8 VDD VSSO n18pcesd L=2.5e-07 W=2.5e-05
M48 VDD 8 VSSO VSSO n18pcesd L=2.5e-07 W=2.5e-05
M49 VSSO 8 VDD VSSO n18pcesd L=2.5e-07 W=2.5e-05
M50 VDD 8 VSSO VSSO n18pcesd L=2.5e-07 W=2.5e-05
M51 VSSO 8 VDD VSSO n18pcesd L=2.5e-07 W=2.5e-05
M52 VDD 8 VSSO VSSO n18pcesd L=2.5e-07 W=2.5e-05
M53 VSSO 8 VDD VSSO n18pcesd L=2.5e-07 W=2.5e-05
M54 VDD 8 VSSO VSSO n18pcesd L=2.5e-07 W=2.5e-05
M55 VSSO 8 VDD VSSO n18pcesd L=2.5e-07 W=2.5e-05
M56 VDDO 7 VSSO VSSO n5pcesd L=6e-07 W=2.5e-05
M57 VSSO 7 VDDO VSSO n5pcesd L=6e-07 W=2.5e-05
M58 VDDO 7 VSSO VSSO n5pcesd L=6e-07 W=2.5e-05
M59 VSSO 7 VDDO VSSO n5pcesd L=6e-07 W=2.5e-05
M60 VDDO 7 VSSO VSSO n5pcesd L=6e-07 W=2.5e-05
M61 VSSO 7 VDDO VSSO n5pcesd L=6e-07 W=2.5e-05
M62 VDDO 7 VSSO VSSO n5pcesd L=6e-07 W=2.5e-05
M63 VSSO 7 VDDO VSSO n5pcesd L=6e-07 W=2.5e-05
M64 VDDO 7 VSSO VSSO n5pcesd L=6e-07 W=2.5e-05
M65 VSSO 7 VDDO VSSO n5pcesd L=6e-07 W=2.5e-05
M66 VDDO 7 VSSO VSSO n5pcesd L=6e-07 W=2.5e-05
M67 VSSO 7 VDDO VSSO n5pcesd L=6e-07 W=2.5e-05
M68 VDDO 7 VSSO VSSO n5pcesd L=6e-07 W=2.5e-05
M69 VSSO 7 VDDO VSSO n5pcesd L=6e-07 W=2.5e-05
M70 VDDO 7 VSSO VSSO n5pcesd L=6e-07 W=2.5e-05
M71 VSSO 7 VDDO VSSO n5pcesd L=6e-07 W=2.5e-05
M72 VDDO 7 VSSO VSSO n5pcesd L=6e-07 W=2.5e-05
M73 VSSO 7 VDDO VSSO n5pcesd L=6e-07 W=2.5e-05
M74 VDDO 7 VSSO VSSO n5pcesd L=6e-07 W=2.5e-05
M75 VSSO 7 VDDO VSSO n5pcesd L=6e-07 W=2.5e-05
D76 VSS VSSO dpnwcpl5 AREA=2.242e-11 PJ=3.25314e-05 nf=1
D77 VSS VSSO dpnwcpl5 AREA=2.242e-11 PJ=3.25314e-05 nf=1
D78 VSS VSSO dpnwcpl5 AREA=2.242e-11 PJ=3.25314e-05 nf=1
D79 VSS VSSO dpnwcpl5 AREA=2.242e-11 PJ=3.25314e-05 nf=1
D80 VSS VSSO dpnwcpl5 AREA=2.242e-11 PJ=3.25314e-05 nf=1
D81 VSS VSSO dpnwcpl5 AREA=2.242e-11 PJ=3.25314e-05 nf=1
D82 VSS VSSO dpnwcpl5 AREA=2.242e-11 PJ=3.25314e-05 nf=1
D83 VSSO VSS dpnwcpl5 AREA=2.242e-11 PJ=3.25314e-05 nf=1
D84 VSSO VSS dpnwcpl5 AREA=2.242e-11 PJ=3.25314e-05 nf=1
D85 VSSO VSS dpnwcpl5 AREA=2.242e-11 PJ=3.25314e-05 nf=1
D86 VSSO VSS dpnwcpl5 AREA=2.242e-11 PJ=3.25314e-05 nf=1
D87 VSSO VSS dpnwcpl5 AREA=2.242e-11 PJ=3.25314e-05 nf=1
D88 VSSO VSS dpnwcpl5 AREA=2.242e-11 PJ=3.25314e-05 nf=1
D89 VSSO VSS dpnwcpl5 AREA=2.242e-11 PJ=3.25314e-05 nf=1
.ENDS

.SUBCKT PV0A_50_50 VSSO VDDO VSS VDD
*.PININFO VSSO:B VDDO:B VSS:B VDD:B
M0 7 VDDO 7 VSSO N5 L=4.55e-06 W=5.5e-06 rf_flag=0
M1 7 VDDO 7 VSSO N5 L=4.55e-06 W=5.5e-06 rf_flag=0
M2 7 VDDO 7 VSSO N5 L=4.55e-06 W=5.5e-06 rf_flag=0
M3 7 VDDO 7 VSSO N5 L=4.55e-06 W=5.5e-06 rf_flag=0
M4 7 VDDO 7 VSSO N5 L=4.55e-06 W=5.5e-06 rf_flag=0
M5 7 VDDO 7 VSSO N5 L=4.55e-06 W=5.5e-06 rf_flag=0
M6 7 VDDO 7 VSSO N5 L=4.55e-06 W=5.5e-06 rf_flag=0
M7 7 VDDO 7 VSSO N5 L=4.55e-06 W=5.5e-06 rf_flag=0
M8 7 VDDO 7 VSSO N5 L=4.55e-06 W=5.5e-06 rf_flag=0
M9 7 VDDO 7 VSSO N5 L=4.55e-06 W=5.5e-06 rf_flag=0
M10 8 VDD 8 VSSO N5 L=4.55e-06 W=5.5e-06 rf_flag=0
M11 8 VDD 8 VSSO N5 L=4.55e-06 W=5.5e-06 rf_flag=0
M12 8 VDD 8 VSSO N5 L=4.55e-06 W=5.5e-06 rf_flag=0
M13 8 VDD 8 VSSO N5 L=4.55e-06 W=5.5e-06 rf_flag=0
M14 8 VDD 8 VSSO N5 L=4.55e-06 W=5.5e-06 rf_flag=0
M15 8 VDD 8 VSSO N5 L=4.55e-06 W=5.5e-06 rf_flag=0
M16 8 VDD 8 VSSO N5 L=4.55e-06 W=5.5e-06 rf_flag=0
M17 8 VDD 8 VSSO N5 L=4.55e-06 W=5.5e-06 rf_flag=0
M18 8 VDD 8 VSSO N5 L=4.55e-06 W=5.5e-06 rf_flag=0
M19 8 VDD 8 VSSO N5 L=4.55e-06 W=5.5e-06 rf_flag=0
R20 5 VSSO 8325.14 L=4e-05 W=2e-06 postlayout=1 $SUB=VSSO $[RE3]
R21 VSSO 6 8325.14 L=4e-05 W=2e-06 postlayout=1 $SUB=VSSO $[RE3]
R22 5 7 8325.14 L=4e-05 W=2e-06 postlayout=1 $SUB=VSSO $[RE3]
R23 8 6 8325.14 L=4e-05 W=2e-06 postlayout=1 $SUB=VSSO $[RE3]
D24 VSS VDDO dwn2psub AREA=8.1276e-10 PJ=0.00080876
D25 VSS VDD dwn2psub AREA=8.1276e-10 PJ=0.00080876
D26 VSSO VDDO dwn2psub AREA=8.1276e-10 PJ=0.00080876
D27 VSSO VDD dwn2psub AREA=8.1276e-10 PJ=0.00080876
D28 VSSO VDDO dwn2psub AREA=8.1276e-10 PJ=0.00080876
D29 VSSO VDD dwn2psub AREA=8.1276e-10 PJ=0.00080876
D30 VSS VDDO dwn2psub AREA=2.7424e-10 PJ=0.00027424
D31 VSS VDDO dwn2psub AREA=2.7392e-10 PJ=0.00027392
D32 VSSO VDDO dwn2psub AREA=2.7424e-10 PJ=0.00027424
D33 VSSO VDDO dwn2psub AREA=2.7392e-10 PJ=0.00027392
D34 VSSO VSSO dwn2psub AREA=6.3709e-10 PJ=0.00010544
D35 VSSO VSS dwn2psub AREA=6.3709e-10 PJ=0.00010544
M36 VDDO 7 VSSO VSSO n5pcesd L=6e-07 W=2.5e-05
M37 VSSO 7 VDDO VSSO n5pcesd L=6e-07 W=2.5e-05
M38 VDDO 7 VSSO VSSO n5pcesd L=6e-07 W=2.5e-05
M39 VSSO 7 VDDO VSSO n5pcesd L=6e-07 W=2.5e-05
M40 VDDO 7 VSSO VSSO n5pcesd L=6e-07 W=2.5e-05
M41 VSSO 7 VDDO VSSO n5pcesd L=6e-07 W=2.5e-05
M42 VDDO 7 VSSO VSSO n5pcesd L=6e-07 W=2.5e-05
M43 VSSO 7 VDDO VSSO n5pcesd L=6e-07 W=2.5e-05
M44 VDDO 7 VSSO VSSO n5pcesd L=6e-07 W=2.5e-05
M45 VSSO 7 VDDO VSSO n5pcesd L=6e-07 W=2.5e-05
M46 VDDO 7 VSSO VSSO n5pcesd L=6e-07 W=2.5e-05
M47 VSSO 7 VDDO VSSO n5pcesd L=6e-07 W=2.5e-05
M48 VDDO 7 VSSO VSSO n5pcesd L=6e-07 W=2.5e-05
M49 VSSO 7 VDDO VSSO n5pcesd L=6e-07 W=2.5e-05
M50 VDDO 7 VSSO VSSO n5pcesd L=6e-07 W=2.5e-05
M51 VSSO 7 VDDO VSSO n5pcesd L=6e-07 W=2.5e-05
M52 VDDO 7 VSSO VSSO n5pcesd L=6e-07 W=2.5e-05
M53 VSSO 7 VDDO VSSO n5pcesd L=6e-07 W=2.5e-05
M54 VDDO 7 VSSO VSSO n5pcesd L=6e-07 W=2.5e-05
M55 VSSO 7 VDDO VSSO n5pcesd L=6e-07 W=2.5e-05
M56 VDD 8 VSSO VSSO n5pcesd L=6e-07 W=2.5e-05
M57 VSSO 8 VDD VSSO n5pcesd L=6e-07 W=2.5e-05
M58 VDD 8 VSSO VSSO n5pcesd L=6e-07 W=2.5e-05
M59 VSSO 8 VDD VSSO n5pcesd L=6e-07 W=2.5e-05
M60 VDD 8 VSSO VSSO n5pcesd L=6e-07 W=2.5e-05
M61 VSSO 8 VDD VSSO n5pcesd L=6e-07 W=2.5e-05
M62 VDD 8 VSSO VSSO n5pcesd L=6e-07 W=2.5e-05
M63 VSSO 8 VDD VSSO n5pcesd L=6e-07 W=2.5e-05
M64 VDD 8 VSSO VSSO n5pcesd L=6e-07 W=2.5e-05
M65 VSSO 8 VDD VSSO n5pcesd L=6e-07 W=2.5e-05
M66 VDD 8 VSSO VSSO n5pcesd L=6e-07 W=2.5e-05
M67 VSSO 8 VDD VSSO n5pcesd L=6e-07 W=2.5e-05
M68 VDD 8 VSSO VSSO n5pcesd L=6e-07 W=2.5e-05
M69 VSSO 8 VDD VSSO n5pcesd L=6e-07 W=2.5e-05
M70 VDD 8 VSSO VSSO n5pcesd L=6e-07 W=2.5e-05
M71 VSSO 8 VDD VSSO n5pcesd L=6e-07 W=2.5e-05
M72 VDD 8 VSSO VSSO n5pcesd L=6e-07 W=2.5e-05
M73 VSSO 8 VDD VSSO n5pcesd L=6e-07 W=2.5e-05
M74 VDD 8 VSSO VSSO n5pcesd L=6e-07 W=2.5e-05
M75 VSSO 8 VDD VSSO n5pcesd L=6e-07 W=2.5e-05
D76 VSS VSSO dpnwcpl5 AREA=2.242e-11 PJ=3.25314e-05 nf=1
D77 VSS VSSO dpnwcpl5 AREA=2.242e-11 PJ=3.25314e-05 nf=1
D78 VSS VSSO dpnwcpl5 AREA=2.242e-11 PJ=3.25314e-05 nf=1
D79 VSS VSSO dpnwcpl5 AREA=2.242e-11 PJ=3.25314e-05 nf=1
D80 VSS VSSO dpnwcpl5 AREA=2.242e-11 PJ=3.25314e-05 nf=1
D81 VSS VSSO dpnwcpl5 AREA=2.242e-11 PJ=3.25314e-05 nf=1
D82 VSS VSSO dpnwcpl5 AREA=2.242e-11 PJ=3.25314e-05 nf=1
D83 VSSO VSS dpnwcpl5 AREA=2.242e-11 PJ=3.25314e-05 nf=1
D84 VSSO VSS dpnwcpl5 AREA=2.242e-11 PJ=3.25314e-05 nf=1
D85 VSSO VSS dpnwcpl5 AREA=2.242e-11 PJ=3.25314e-05 nf=1
D86 VSSO VSS dpnwcpl5 AREA=2.242e-11 PJ=3.25314e-05 nf=1
D87 VSSO VSS dpnwcpl5 AREA=2.242e-11 PJ=3.25314e-05 nf=1
D88 VSSO VSS dpnwcpl5 AREA=2.242e-11 PJ=3.25314e-05 nf=1
D89 VSSO VSS dpnwcpl5 AREA=2.242e-11 PJ=3.25314e-05 nf=1
.ENDS

.SUBCKT PV0C_18_18_18 VSSC VDDO VSSO VSS VDD VDDC
*.PININFO VSSC:B VDDO:B VSSO:B VSS:B VDD:B VDDC:B
M0 7 VDDO 7 VSSC N L=5e-06 W=5e-06 rf_flag=0
M1 7 VDDO 7 VSSC N L=5e-06 W=5e-06 rf_flag=0
M2 7 VDDO 7 VSSC N L=5e-06 W=5e-06 rf_flag=0
M3 7 VDDO 7 VSSC N L=5e-06 W=5e-06 rf_flag=0
M4 7 VDDO 7 VSSC N L=5e-06 W=5e-06 rf_flag=0
M5 7 VDDO 7 VSSC N L=5e-06 W=5e-06 rf_flag=0
M6 7 VDDO 7 VSSC N L=5e-06 W=5e-06 rf_flag=0
M7 7 VDDO 7 VSSC N L=5e-06 W=5e-06 rf_flag=0
M8 7 VDDO 7 VSSC N L=5e-06 W=5e-06 rf_flag=0
M9 7 VDDO 7 VSSC N L=5e-06 W=5e-06 rf_flag=0
M10 9 VDDC 9 VSSC N L=5e-06 W=5e-06 rf_flag=0
M11 9 VDDC 9 VSSC N L=5e-06 W=5e-06 rf_flag=0
M12 9 VDDC 9 VSSC N L=5e-06 W=5e-06 rf_flag=0
M13 9 VDDC 9 VSSC N L=5e-06 W=5e-06 rf_flag=0
M14 9 VDDC 9 VSSC N L=5e-06 W=5e-06 rf_flag=0
M15 9 VDDC 9 VSSC N L=5e-06 W=5e-06 rf_flag=0
M16 9 VDDC 9 VSSC N L=5e-06 W=5e-06 rf_flag=0
M17 9 VDDC 9 VSSC N L=5e-06 W=5e-06 rf_flag=0
M18 9 VDDC 9 VSSC N L=5e-06 W=5e-06 rf_flag=0
M19 9 VDDC 9 VSSC N L=5e-06 W=5e-06 rf_flag=0
M20 12 VDD 12 VSSC N L=5e-06 W=5e-06 rf_flag=0
M21 12 VDD 12 VSSC N L=5e-06 W=5e-06 rf_flag=0
M22 12 VDD 12 VSSC N L=5e-06 W=5e-06 rf_flag=0
M23 12 VDD 12 VSSC N L=5e-06 W=5e-06 rf_flag=0
M24 12 VDD 12 VSSC N L=5e-06 W=5e-06 rf_flag=0
M25 12 VDD 12 VSSC N L=5e-06 W=5e-06 rf_flag=0
M26 12 VDD 12 VSSC N L=5e-06 W=5e-06 rf_flag=0
M27 12 VDD 12 VSSC N L=5e-06 W=5e-06 rf_flag=0
M28 12 VDD 12 VSSC N L=5e-06 W=5e-06 rf_flag=0
M29 12 VDD 12 VSSC N L=5e-06 W=5e-06 rf_flag=0
R30 6 7 8325.14 L=4e-05 W=2e-06 postlayout=1 $SUB=VSSC $[RE3]
R31 8 9 8325.14 L=4e-05 W=2e-06 postlayout=1 $SUB=VSSC $[RE3]
R32 6 VSSC 8325.14 L=4e-05 W=2e-06 postlayout=1 $SUB=VSSC $[RE3]
R33 8 VSSC 8325.14 L=4e-05 W=2e-06 postlayout=1 $SUB=VSSC $[RE3]
R34 11 12 8325.14 L=4e-05 W=2e-06 postlayout=1 $SUB=VSSC $[RE3]
R35 11 VSSC 8325.14 L=4e-05 W=2e-06 postlayout=1 $SUB=VSSC $[RE3]
D36 VSS VDDO dwn2psub AREA=8.13573e-10 PJ=0.00080375
D37 VSS VDDC dwn2psub AREA=8.10766e-10 PJ=0.00080363
D38 VSSC VDDO dwn2psub AREA=8.13573e-10 PJ=0.00080375
D39 VSSC VDDC dwn2psub AREA=8.10766e-10 PJ=0.00080363
D40 VSSC VDDO dwn2psub AREA=8.13573e-10 PJ=0.00080375
D41 VSSC VDDC dwn2psub AREA=8.10766e-10 PJ=0.00080363
D42 VSS VDDO dwn2psub AREA=1.08515e-09 PJ=0.00086382
D43 VSS VDD dwn2psub AREA=8.13603e-10 PJ=0.00080378
D44 VSSO VDDO dwn2psub AREA=1.08515e-09 PJ=0.00086382
D45 VSS VDDO dwn2psub AREA=1.08515e-09 PJ=0.00086382
D46 VSSC VDD dwn2psub AREA=8.13603e-10 PJ=0.00080378
D47 VSSO VSSC dwn2psub AREA=6.3409e-10 PJ=0.00011544
D48 VSS VSSC dwn2psub AREA=6.3409e-10 PJ=0.00011544
D49 VSSC VDD dwn2psub AREA=8.13603e-10 PJ=0.00080378
D50 VSSO VDDO dwn2psub AREA=1.08515e-09 PJ=0.00086382
D51 VSS VDDO dwn2psub AREA=1.08515e-09 PJ=0.00086382
D52 VSSO VSSO dwn2psub AREA=6.3409e-10 PJ=0.00011544
D53 VSS VSS dwn2psub AREA=6.3409e-10 PJ=0.00011544
M54 VDDO 7 VSSC VSSC n18pcesd L=2.5e-07 W=2.5e-05
M55 VSSC 7 VDDO VSSC n18pcesd L=2.5e-07 W=2.5e-05
M56 VDDO 7 VSSC VSSC n18pcesd L=2.5e-07 W=2.5e-05
M57 VSSC 7 VDDO VSSC n18pcesd L=2.5e-07 W=2.5e-05
M58 VDDO 7 VSSC VSSC n18pcesd L=2.5e-07 W=2.5e-05
M59 VSSC 7 VDDO VSSC n18pcesd L=2.5e-07 W=2.5e-05
M60 VDDO 7 VSSC VSSC n18pcesd L=2.5e-07 W=2.5e-05
M61 VSSC 7 VDDO VSSC n18pcesd L=2.5e-07 W=2.5e-05
M62 VDDO 7 VSSC VSSC n18pcesd L=2.5e-07 W=2.5e-05
M63 VSSC 7 VDDO VSSC n18pcesd L=2.5e-07 W=2.5e-05
M64 VDDO 7 VSSC VSSC n18pcesd L=2.5e-07 W=2.5e-05
M65 VSSC 7 VDDO VSSC n18pcesd L=2.5e-07 W=2.5e-05
M66 VDDO 7 VSSC VSSC n18pcesd L=2.5e-07 W=2.5e-05
M67 VSSC 7 VDDO VSSC n18pcesd L=2.5e-07 W=2.5e-05
M68 VDDO 7 VSSC VSSC n18pcesd L=2.5e-07 W=2.5e-05
M69 VSSC 7 VDDO VSSC n18pcesd L=2.5e-07 W=2.5e-05
M70 VDDO 7 VSSC VSSC n18pcesd L=2.5e-07 W=2.5e-05
M71 VSSC 7 VDDO VSSC n18pcesd L=2.5e-07 W=2.5e-05
M72 VDDO 7 VSSC VSSC n18pcesd L=2.5e-07 W=2.5e-05
M73 VSSC 7 VDDO VSSC n18pcesd L=2.5e-07 W=2.5e-05
M74 VDDC 9 VSSC VSSC n18pcesd L=2.5e-07 W=2.5e-05
M75 VSSC 9 VDDC VSSC n18pcesd L=2.5e-07 W=2.5e-05
M76 VDDC 9 VSSC VSSC n18pcesd L=2.5e-07 W=2.5e-05
M77 VSSC 9 VDDC VSSC n18pcesd L=2.5e-07 W=2.5e-05
M78 VDDC 9 VSSC VSSC n18pcesd L=2.5e-07 W=2.5e-05
M79 VSSC 9 VDDC VSSC n18pcesd L=2.5e-07 W=2.5e-05
M80 VDDC 9 VSSC VSSC n18pcesd L=2.5e-07 W=2.5e-05
M81 VSSC 9 VDDC VSSC n18pcesd L=2.5e-07 W=2.5e-05
M82 VDDC 9 VSSC VSSC n18pcesd L=2.5e-07 W=2.5e-05
M83 VSSC 9 VDDC VSSC n18pcesd L=2.5e-07 W=2.5e-05
M84 VDDC 9 VSSC VSSC n18pcesd L=2.5e-07 W=2.5e-05
M85 VSSC 9 VDDC VSSC n18pcesd L=2.5e-07 W=2.5e-05
M86 VDDC 9 VSSC VSSC n18pcesd L=2.5e-07 W=2.5e-05
M87 VSSC 9 VDDC VSSC n18pcesd L=2.5e-07 W=2.5e-05
M88 VDDC 9 VSSC VSSC n18pcesd L=2.5e-07 W=2.5e-05
M89 VSSC 9 VDDC VSSC n18pcesd L=2.5e-07 W=2.5e-05
M90 VDDC 9 VSSC VSSC n18pcesd L=2.5e-07 W=2.5e-05
M91 VSSC 9 VDDC VSSC n18pcesd L=2.5e-07 W=2.5e-05
M92 VDDC 9 VSSC VSSC n18pcesd L=2.5e-07 W=2.5e-05
M93 VSSC 9 VDDC VSSC n18pcesd L=2.5e-07 W=2.5e-05
M94 VDD 12 VSSC VSSC n18pcesd L=2.5e-07 W=2.5e-05
M95 VSSC 12 VDD VSSC n18pcesd L=2.5e-07 W=2.5e-05
M96 VDD 12 VSSC VSSC n18pcesd L=2.5e-07 W=2.5e-05
M97 VSSC 12 VDD VSSC n18pcesd L=2.5e-07 W=2.5e-05
M98 VDD 12 VSSC VSSC n18pcesd L=2.5e-07 W=2.5e-05
M99 VSSC 12 VDD VSSC n18pcesd L=2.5e-07 W=2.5e-05
M100 VDD 12 VSSC VSSC n18pcesd L=2.5e-07 W=2.5e-05
M101 VSSC 12 VDD VSSC n18pcesd L=2.5e-07 W=2.5e-05
M102 VDD 12 VSSC VSSC n18pcesd L=2.5e-07 W=2.5e-05
M103 VSSC 12 VDD VSSC n18pcesd L=2.5e-07 W=2.5e-05
M104 VDD 12 VSSC VSSC n18pcesd L=2.5e-07 W=2.5e-05
M105 VSSC 12 VDD VSSC n18pcesd L=2.5e-07 W=2.5e-05
M106 VDD 12 VSSC VSSC n18pcesd L=2.5e-07 W=2.5e-05
M107 VSSC 12 VDD VSSC n18pcesd L=2.5e-07 W=2.5e-05
M108 VDD 12 VSSC VSSC n18pcesd L=2.5e-07 W=2.5e-05
M109 VSSC 12 VDD VSSC n18pcesd L=2.5e-07 W=2.5e-05
M110 VDD 12 VSSC VSSC n18pcesd L=2.5e-07 W=2.5e-05
M111 VSSC 12 VDD VSSC n18pcesd L=2.5e-07 W=2.5e-05
M112 VDD 12 VSSC VSSC n18pcesd L=2.5e-07 W=2.5e-05
M113 VSSC 12 VDD VSSC n18pcesd L=2.5e-07 W=2.5e-05
D114 VSSO VSSC dpnwcpl18 AREA=1.642e-11 PJ=2.45314e-05 nf=1
D115 VSSO VSSC dpnwcpl18 AREA=1.642e-11 PJ=2.45314e-05 nf=1
D116 VSSO VSSC dpnwcpl18 AREA=1.642e-11 PJ=2.45314e-05 nf=1
D117 VSSO VSSC dpnwcpl18 AREA=1.642e-11 PJ=2.45314e-05 nf=1
D118 VSSO VSSC dpnwcpl18 AREA=1.642e-11 PJ=2.45314e-05 nf=1
D119 VSSO VSSC dpnwcpl18 AREA=1.642e-11 PJ=2.45314e-05 nf=1
D120 VSSO VSSC dpnwcpl18 AREA=1.642e-11 PJ=2.45314e-05 nf=1
D121 VSSO VSSC dpnwcpl18 AREA=1.642e-11 PJ=2.45314e-05 nf=1
D122 VSSO VSSC dpnwcpl18 AREA=1.642e-11 PJ=2.45314e-05 nf=1
D123 VSS VSSC dpnwcpl18 AREA=1.642e-11 PJ=2.45314e-05 nf=1
D124 VSS VSSC dpnwcpl18 AREA=1.642e-11 PJ=2.45314e-05 nf=1
D125 VSS VSSC dpnwcpl18 AREA=1.642e-11 PJ=2.45314e-05 nf=1
D126 VSS VSSC dpnwcpl18 AREA=1.642e-11 PJ=2.45314e-05 nf=1
D127 VSS VSSC dpnwcpl18 AREA=1.642e-11 PJ=2.45314e-05 nf=1
D128 VSS VSSC dpnwcpl18 AREA=1.642e-11 PJ=2.45314e-05 nf=1
D129 VSS VSSC dpnwcpl18 AREA=1.642e-11 PJ=2.45314e-05 nf=1
D130 VSS VSSC dpnwcpl18 AREA=1.642e-11 PJ=2.45314e-05 nf=1
D131 VSS VSSC dpnwcpl18 AREA=1.642e-11 PJ=2.45314e-05 nf=1
D132 VSSC VSSO dpnwcpl18 AREA=1.642e-11 PJ=2.45314e-05 nf=1
D133 VSSC VSSO dpnwcpl18 AREA=1.642e-11 PJ=2.45314e-05 nf=1
D134 VSSC VSSO dpnwcpl18 AREA=1.642e-11 PJ=2.45314e-05 nf=1
D135 VSSC VSSO dpnwcpl18 AREA=1.642e-11 PJ=2.45314e-05 nf=1
D136 VSSC VSSO dpnwcpl18 AREA=1.642e-11 PJ=2.45314e-05 nf=1
D137 VSSC VSSO dpnwcpl18 AREA=1.642e-11 PJ=2.45314e-05 nf=1
D138 VSSC VSSO dpnwcpl18 AREA=1.642e-11 PJ=2.45314e-05 nf=1
D139 VSSC VSSO dpnwcpl18 AREA=1.642e-11 PJ=2.45314e-05 nf=1
D140 VSSC VSSO dpnwcpl18 AREA=1.642e-11 PJ=2.45314e-05 nf=1
D141 VSSC VSS dpnwcpl18 AREA=1.642e-11 PJ=2.45314e-05 nf=1
D142 VSSC VSS dpnwcpl18 AREA=1.642e-11 PJ=2.45314e-05 nf=1
D143 VSSC VSS dpnwcpl18 AREA=1.642e-11 PJ=2.45314e-05 nf=1
D144 VSSC VSS dpnwcpl18 AREA=1.642e-11 PJ=2.45314e-05 nf=1
D145 VSSC VSS dpnwcpl18 AREA=1.642e-11 PJ=2.45314e-05 nf=1
D146 VSSC VSS dpnwcpl18 AREA=1.642e-11 PJ=2.45314e-05 nf=1
D147 VSSC VSS dpnwcpl18 AREA=1.642e-11 PJ=2.45314e-05 nf=1
D148 VSSC VSS dpnwcpl18 AREA=1.642e-11 PJ=2.45314e-05 nf=1
D149 VSSC VSS dpnwcpl18 AREA=1.642e-11 PJ=2.45314e-05 nf=1
.ENDS

.SUBCKT PV0C_50_18_18 VSSC VDDO VSSO VSS VDD VDDC
*.PININFO VSSC:B VDDO:B VSSO:B VSS:B VDD:B VDDC:B
M0 7 VDDO 7 VSSC N5 L=5e-06 W=5e-06 rf_flag=0
M1 7 VDDO 7 VSSC N5 L=5e-06 W=5e-06 rf_flag=0
M2 7 VDDO 7 VSSC N5 L=5e-06 W=5e-06 rf_flag=0
M3 7 VDDO 7 VSSC N5 L=5e-06 W=5e-06 rf_flag=0
M4 7 VDDO 7 VSSC N5 L=5e-06 W=5e-06 rf_flag=0
M5 7 VDDO 7 VSSC N5 L=5e-06 W=5e-06 rf_flag=0
M6 7 VDDO 7 VSSC N5 L=5e-06 W=5e-06 rf_flag=0
M7 7 VDDO 7 VSSC N5 L=5e-06 W=5e-06 rf_flag=0
M8 7 VDDO 7 VSSC N5 L=5e-06 W=5e-06 rf_flag=0
M9 7 VDDO 7 VSSC N5 L=5e-06 W=5e-06 rf_flag=0
M10 9 VDDC 9 VSSC N L=5e-06 W=5e-06 rf_flag=0
M11 9 VDDC 9 VSSC N L=5e-06 W=5e-06 rf_flag=0
M12 9 VDDC 9 VSSC N L=5e-06 W=5e-06 rf_flag=0
M13 9 VDDC 9 VSSC N L=5e-06 W=5e-06 rf_flag=0
M14 9 VDDC 9 VSSC N L=5e-06 W=5e-06 rf_flag=0
M15 9 VDDC 9 VSSC N L=5e-06 W=5e-06 rf_flag=0
M16 9 VDDC 9 VSSC N L=5e-06 W=5e-06 rf_flag=0
M17 9 VDDC 9 VSSC N L=5e-06 W=5e-06 rf_flag=0
M18 9 VDDC 9 VSSC N L=5e-06 W=5e-06 rf_flag=0
M19 9 VDDC 9 VSSC N L=5e-06 W=5e-06 rf_flag=0
M20 12 VDD 12 VSSC N L=5e-06 W=5e-06 rf_flag=0
M21 12 VDD 12 VSSC N L=5e-06 W=5e-06 rf_flag=0
M22 12 VDD 12 VSSC N L=5e-06 W=5e-06 rf_flag=0
M23 12 VDD 12 VSSC N L=5e-06 W=5e-06 rf_flag=0
M24 12 VDD 12 VSSC N L=5e-06 W=5e-06 rf_flag=0
M25 12 VDD 12 VSSC N L=5e-06 W=5e-06 rf_flag=0
M26 12 VDD 12 VSSC N L=5e-06 W=5e-06 rf_flag=0
M27 12 VDD 12 VSSC N L=5e-06 W=5e-06 rf_flag=0
M28 12 VDD 12 VSSC N L=5e-06 W=5e-06 rf_flag=0
M29 12 VDD 12 VSSC N L=5e-06 W=5e-06 rf_flag=0
R30 6 7 8325.14 L=4e-05 W=2e-06 postlayout=1 $SUB=VSSC $[RE3]
R31 8 9 8325.14 L=4e-05 W=2e-06 postlayout=1 $SUB=VSSC $[RE3]
R32 6 VSSC 8325.14 L=4e-05 W=2e-06 postlayout=1 $SUB=VSSC $[RE3]
R33 8 VSSC 8325.14 L=4e-05 W=2e-06 postlayout=1 $SUB=VSSC $[RE3]
R34 11 12 8325.14 L=4e-05 W=2e-06 postlayout=1 $SUB=VSSC $[RE3]
R35 11 VSSC 8325.14 L=4e-05 W=2e-06 postlayout=1 $SUB=VSSC $[RE3]
D36 VSS VDDO dwn2psub AREA=8.13573e-10 PJ=0.00080375
D37 VSS VDDC dwn2psub AREA=8.10766e-10 PJ=0.00080363
D38 VSSC VDDO dwn2psub AREA=8.13573e-10 PJ=0.00080375
D39 VSSC VDDC dwn2psub AREA=8.10766e-10 PJ=0.00080363
D40 VSSC VDDO dwn2psub AREA=8.13573e-10 PJ=0.00080375
D41 VSSC VDDC dwn2psub AREA=8.10766e-10 PJ=0.00080363
D42 VSS VDDO dwn2psub AREA=1.08515e-09 PJ=0.00086382
D43 VSS VDD dwn2psub AREA=8.13603e-10 PJ=0.00080378
D44 VSSO VDDO dwn2psub AREA=1.08515e-09 PJ=0.00086382
D45 VSS VDDO dwn2psub AREA=1.08515e-09 PJ=0.00086382
D46 VSSC VDD dwn2psub AREA=8.13603e-10 PJ=0.00080378
D47 VSSO VSSC dwn2psub AREA=6.3409e-10 PJ=0.00011544
D48 VSS VSSC dwn2psub AREA=6.3409e-10 PJ=0.00011544
D49 VSSC VDD dwn2psub AREA=8.13603e-10 PJ=0.00080378
D50 VSSO VDDO dwn2psub AREA=1.08515e-09 PJ=0.00086382
D51 VSS VDDO dwn2psub AREA=1.08515e-09 PJ=0.00086382
D52 VSSO VSSO dwn2psub AREA=6.3409e-10 PJ=0.00011544
D53 VSS VSS dwn2psub AREA=6.3409e-10 PJ=0.00011544
M54 VDDC 9 VSSC VSSC n18pcesd L=2.5e-07 W=2.5e-05
M55 VSSC 9 VDDC VSSC n18pcesd L=2.5e-07 W=2.5e-05
M56 VDDC 9 VSSC VSSC n18pcesd L=2.5e-07 W=2.5e-05
M57 VSSC 9 VDDC VSSC n18pcesd L=2.5e-07 W=2.5e-05
M58 VDDC 9 VSSC VSSC n18pcesd L=2.5e-07 W=2.5e-05
M59 VSSC 9 VDDC VSSC n18pcesd L=2.5e-07 W=2.5e-05
M60 VDDC 9 VSSC VSSC n18pcesd L=2.5e-07 W=2.5e-05
M61 VSSC 9 VDDC VSSC n18pcesd L=2.5e-07 W=2.5e-05
M62 VDDC 9 VSSC VSSC n18pcesd L=2.5e-07 W=2.5e-05
M63 VSSC 9 VDDC VSSC n18pcesd L=2.5e-07 W=2.5e-05
M64 VDDC 9 VSSC VSSC n18pcesd L=2.5e-07 W=2.5e-05
M65 VSSC 9 VDDC VSSC n18pcesd L=2.5e-07 W=2.5e-05
M66 VDDC 9 VSSC VSSC n18pcesd L=2.5e-07 W=2.5e-05
M67 VSSC 9 VDDC VSSC n18pcesd L=2.5e-07 W=2.5e-05
M68 VDDC 9 VSSC VSSC n18pcesd L=2.5e-07 W=2.5e-05
M69 VSSC 9 VDDC VSSC n18pcesd L=2.5e-07 W=2.5e-05
M70 VDDC 9 VSSC VSSC n18pcesd L=2.5e-07 W=2.5e-05
M71 VSSC 9 VDDC VSSC n18pcesd L=2.5e-07 W=2.5e-05
M72 VDDC 9 VSSC VSSC n18pcesd L=2.5e-07 W=2.5e-05
M73 VSSC 9 VDDC VSSC n18pcesd L=2.5e-07 W=2.5e-05
M74 VDD 12 VSSC VSSC n18pcesd L=2.5e-07 W=2.5e-05
M75 VSSC 12 VDD VSSC n18pcesd L=2.5e-07 W=2.5e-05
M76 VDD 12 VSSC VSSC n18pcesd L=2.5e-07 W=2.5e-05
M77 VSSC 12 VDD VSSC n18pcesd L=2.5e-07 W=2.5e-05
M78 VDD 12 VSSC VSSC n18pcesd L=2.5e-07 W=2.5e-05
M79 VSSC 12 VDD VSSC n18pcesd L=2.5e-07 W=2.5e-05
M80 VDD 12 VSSC VSSC n18pcesd L=2.5e-07 W=2.5e-05
M81 VSSC 12 VDD VSSC n18pcesd L=2.5e-07 W=2.5e-05
M82 VDD 12 VSSC VSSC n18pcesd L=2.5e-07 W=2.5e-05
M83 VSSC 12 VDD VSSC n18pcesd L=2.5e-07 W=2.5e-05
M84 VDD 12 VSSC VSSC n18pcesd L=2.5e-07 W=2.5e-05
M85 VSSC 12 VDD VSSC n18pcesd L=2.5e-07 W=2.5e-05
M86 VDD 12 VSSC VSSC n18pcesd L=2.5e-07 W=2.5e-05
M87 VSSC 12 VDD VSSC n18pcesd L=2.5e-07 W=2.5e-05
M88 VDD 12 VSSC VSSC n18pcesd L=2.5e-07 W=2.5e-05
M89 VSSC 12 VDD VSSC n18pcesd L=2.5e-07 W=2.5e-05
M90 VDD 12 VSSC VSSC n18pcesd L=2.5e-07 W=2.5e-05
M91 VSSC 12 VDD VSSC n18pcesd L=2.5e-07 W=2.5e-05
M92 VDD 12 VSSC VSSC n18pcesd L=2.5e-07 W=2.5e-05
M93 VSSC 12 VDD VSSC n18pcesd L=2.5e-07 W=2.5e-05
M94 VDDO 7 VSSC VSSC n5pcesd L=6e-07 W=2.5e-05
M95 VSSC 7 VDDO VSSC n5pcesd L=6e-07 W=2.5e-05
M96 VDDO 7 VSSC VSSC n5pcesd L=6e-07 W=2.5e-05
M97 VSSC 7 VDDO VSSC n5pcesd L=6e-07 W=2.5e-05
M98 VDDO 7 VSSC VSSC n5pcesd L=6e-07 W=2.5e-05
M99 VSSC 7 VDDO VSSC n5pcesd L=6e-07 W=2.5e-05
M100 VDDO 7 VSSC VSSC n5pcesd L=6e-07 W=2.5e-05
M101 VSSC 7 VDDO VSSC n5pcesd L=6e-07 W=2.5e-05
M102 VDDO 7 VSSC VSSC n5pcesd L=6e-07 W=2.5e-05
M103 VSSC 7 VDDO VSSC n5pcesd L=6e-07 W=2.5e-05
M104 VDDO 7 VSSC VSSC n5pcesd L=6e-07 W=2.5e-05
M105 VSSC 7 VDDO VSSC n5pcesd L=6e-07 W=2.5e-05
M106 VDDO 7 VSSC VSSC n5pcesd L=6e-07 W=2.5e-05
M107 VSSC 7 VDDO VSSC n5pcesd L=6e-07 W=2.5e-05
M108 VDDO 7 VSSC VSSC n5pcesd L=6e-07 W=2.5e-05
M109 VSSC 7 VDDO VSSC n5pcesd L=6e-07 W=2.5e-05
M110 VDDO 7 VSSC VSSC n5pcesd L=6e-07 W=2.5e-05
M111 VSSC 7 VDDO VSSC n5pcesd L=6e-07 W=2.5e-05
M112 VDDO 7 VSSC VSSC n5pcesd L=6e-07 W=2.5e-05
M113 VSSC 7 VDDO VSSC n5pcesd L=6e-07 W=2.5e-05
D114 VSSO VSSC dpnwcpl5 AREA=1.642e-11 PJ=2.45314e-05 nf=1
D115 VSSO VSSC dpnwcpl5 AREA=1.642e-11 PJ=2.45314e-05 nf=1
D116 VSSO VSSC dpnwcpl5 AREA=1.642e-11 PJ=2.45314e-05 nf=1
D117 VSSO VSSC dpnwcpl5 AREA=1.642e-11 PJ=2.45314e-05 nf=1
D118 VSSO VSSC dpnwcpl5 AREA=1.642e-11 PJ=2.45314e-05 nf=1
D119 VSSO VSSC dpnwcpl5 AREA=1.642e-11 PJ=2.45314e-05 nf=1
D120 VSSO VSSC dpnwcpl5 AREA=1.642e-11 PJ=2.45314e-05 nf=1
D121 VSSO VSSC dpnwcpl5 AREA=1.642e-11 PJ=2.45314e-05 nf=1
D122 VSSO VSSC dpnwcpl5 AREA=1.642e-11 PJ=2.45314e-05 nf=1
D123 VSS VSSC dpnwcpl5 AREA=1.642e-11 PJ=2.45314e-05 nf=1
D124 VSS VSSC dpnwcpl5 AREA=1.642e-11 PJ=2.45314e-05 nf=1
D125 VSS VSSC dpnwcpl5 AREA=1.642e-11 PJ=2.45314e-05 nf=1
D126 VSS VSSC dpnwcpl5 AREA=1.642e-11 PJ=2.45314e-05 nf=1
D127 VSS VSSC dpnwcpl5 AREA=1.642e-11 PJ=2.45314e-05 nf=1
D128 VSS VSSC dpnwcpl5 AREA=1.642e-11 PJ=2.45314e-05 nf=1
D129 VSS VSSC dpnwcpl5 AREA=1.642e-11 PJ=2.45314e-05 nf=1
D130 VSS VSSC dpnwcpl5 AREA=1.642e-11 PJ=2.45314e-05 nf=1
D131 VSS VSSC dpnwcpl5 AREA=1.642e-11 PJ=2.45314e-05 nf=1
D132 VSSC VSSO dpnwcpl5 AREA=1.642e-11 PJ=2.45314e-05 nf=1
D133 VSSC VSSO dpnwcpl5 AREA=1.642e-11 PJ=2.45314e-05 nf=1
D134 VSSC VSSO dpnwcpl5 AREA=1.642e-11 PJ=2.45314e-05 nf=1
D135 VSSC VSSO dpnwcpl5 AREA=1.642e-11 PJ=2.45314e-05 nf=1
D136 VSSC VSSO dpnwcpl5 AREA=1.642e-11 PJ=2.45314e-05 nf=1
D137 VSSC VSSO dpnwcpl5 AREA=1.642e-11 PJ=2.45314e-05 nf=1
D138 VSSC VSSO dpnwcpl5 AREA=1.642e-11 PJ=2.45314e-05 nf=1
D139 VSSC VSSO dpnwcpl5 AREA=1.642e-11 PJ=2.45314e-05 nf=1
D140 VSSC VSSO dpnwcpl5 AREA=1.642e-11 PJ=2.45314e-05 nf=1
D141 VSSC VSS dpnwcpl5 AREA=1.642e-11 PJ=2.45314e-05 nf=1
D142 VSSC VSS dpnwcpl5 AREA=1.642e-11 PJ=2.45314e-05 nf=1
D143 VSSC VSS dpnwcpl5 AREA=1.642e-11 PJ=2.45314e-05 nf=1
D144 VSSC VSS dpnwcpl5 AREA=1.642e-11 PJ=2.45314e-05 nf=1
D145 VSSC VSS dpnwcpl5 AREA=1.642e-11 PJ=2.45314e-05 nf=1
D146 VSSC VSS dpnwcpl5 AREA=1.642e-11 PJ=2.45314e-05 nf=1
D147 VSSC VSS dpnwcpl5 AREA=1.642e-11 PJ=2.45314e-05 nf=1
D148 VSSC VSS dpnwcpl5 AREA=1.642e-11 PJ=2.45314e-05 nf=1
D149 VSSC VSS dpnwcpl5 AREA=1.642e-11 PJ=2.45314e-05 nf=1
.ENDS

.SUBCKT PV0C_50_18_50 VSSC VDDO VSSO VSS VDD VDDC
*.PININFO VSSC:B VDDO:B VSSO:B VSS:B VDD:B VDDC:B
M0 7 VDDO 7 VSSC N5 L=5e-06 W=5e-06 rf_flag=0
M1 7 VDDO 7 VSSC N5 L=5e-06 W=5e-06 rf_flag=0
M2 7 VDDO 7 VSSC N5 L=5e-06 W=5e-06 rf_flag=0
M3 7 VDDO 7 VSSC N5 L=5e-06 W=5e-06 rf_flag=0
M4 7 VDDO 7 VSSC N5 L=5e-06 W=5e-06 rf_flag=0
M5 7 VDDO 7 VSSC N5 L=5e-06 W=5e-06 rf_flag=0
M6 7 VDDO 7 VSSC N5 L=5e-06 W=5e-06 rf_flag=0
M7 7 VDDO 7 VSSC N5 L=5e-06 W=5e-06 rf_flag=0
M8 7 VDDO 7 VSSC N5 L=5e-06 W=5e-06 rf_flag=0
M9 7 VDDO 7 VSSC N5 L=5e-06 W=5e-06 rf_flag=0
M10 9 VDDC 9 VSSC N5 L=5e-06 W=5e-06 rf_flag=0
M11 9 VDDC 9 VSSC N5 L=5e-06 W=5e-06 rf_flag=0
M12 9 VDDC 9 VSSC N5 L=5e-06 W=5e-06 rf_flag=0
M13 9 VDDC 9 VSSC N5 L=5e-06 W=5e-06 rf_flag=0
M14 9 VDDC 9 VSSC N5 L=5e-06 W=5e-06 rf_flag=0
M15 9 VDDC 9 VSSC N5 L=5e-06 W=5e-06 rf_flag=0
M16 9 VDDC 9 VSSC N5 L=5e-06 W=5e-06 rf_flag=0
M17 9 VDDC 9 VSSC N5 L=5e-06 W=5e-06 rf_flag=0
M18 9 VDDC 9 VSSC N5 L=5e-06 W=5e-06 rf_flag=0
M19 9 VDDC 9 VSSC N5 L=5e-06 W=5e-06 rf_flag=0
M20 12 VDD 12 VSSC N L=5e-06 W=5e-06 rf_flag=0
M21 12 VDD 12 VSSC N L=5e-06 W=5e-06 rf_flag=0
M22 12 VDD 12 VSSC N L=5e-06 W=5e-06 rf_flag=0
M23 12 VDD 12 VSSC N L=5e-06 W=5e-06 rf_flag=0
M24 12 VDD 12 VSSC N L=5e-06 W=5e-06 rf_flag=0
M25 12 VDD 12 VSSC N L=5e-06 W=5e-06 rf_flag=0
M26 12 VDD 12 VSSC N L=5e-06 W=5e-06 rf_flag=0
M27 12 VDD 12 VSSC N L=5e-06 W=5e-06 rf_flag=0
M28 12 VDD 12 VSSC N L=5e-06 W=5e-06 rf_flag=0
M29 12 VDD 12 VSSC N L=5e-06 W=5e-06 rf_flag=0
R30 6 7 8325.14 L=4e-05 W=2e-06 postlayout=1 $SUB=VSSC $[RE3]
R31 8 9 8325.14 L=4e-05 W=2e-06 postlayout=1 $SUB=VSSC $[RE3]
R32 6 VSSC 8325.14 L=4e-05 W=2e-06 postlayout=1 $SUB=VSSC $[RE3]
R33 8 VSSC 8325.14 L=4e-05 W=2e-06 postlayout=1 $SUB=VSSC $[RE3]
R34 11 12 8325.14 L=4e-05 W=2e-06 postlayout=1 $SUB=VSSC $[RE3]
R35 11 VSSC 8325.14 L=4e-05 W=2e-06 postlayout=1 $SUB=VSSC $[RE3]
D36 VSS VDDO dwn2psub AREA=8.13573e-10 PJ=0.00080375
D37 VSS VDDC dwn2psub AREA=8.10766e-10 PJ=0.00080363
D38 VSSC VDDO dwn2psub AREA=8.13573e-10 PJ=0.00080375
D39 VSSC VDDC dwn2psub AREA=8.10766e-10 PJ=0.00080363
D40 VSSC VDDO dwn2psub AREA=8.13573e-10 PJ=0.00080375
D41 VSSC VDDC dwn2psub AREA=8.10766e-10 PJ=0.00080363
D42 VSS VDDO dwn2psub AREA=1.08515e-09 PJ=0.00086382
D43 VSS VDD dwn2psub AREA=8.13603e-10 PJ=0.00080378
D44 VSSO VDDO dwn2psub AREA=1.08515e-09 PJ=0.00086382
D45 VSS VDDO dwn2psub AREA=1.08515e-09 PJ=0.00086382
D46 VSSC VDD dwn2psub AREA=8.13603e-10 PJ=0.00080378
D47 VSSO VSSC dwn2psub AREA=6.3409e-10 PJ=0.00011544
D48 VSS VSSC dwn2psub AREA=6.3409e-10 PJ=0.00011544
D49 VSSC VDD dwn2psub AREA=8.13603e-10 PJ=0.00080378
D50 VSSO VDDO dwn2psub AREA=1.08515e-09 PJ=0.00086382
D51 VSS VDDO dwn2psub AREA=1.08515e-09 PJ=0.00086382
D52 VSSO VSSO dwn2psub AREA=6.3409e-10 PJ=0.00011544
D53 VSS VSS dwn2psub AREA=6.3409e-10 PJ=0.00011544
M54 VDD 12 VSSC VSSC n18pcesd L=2.5e-07 W=2.5e-05
M55 VSSC 12 VDD VSSC n18pcesd L=2.5e-07 W=2.5e-05
M56 VDD 12 VSSC VSSC n18pcesd L=2.5e-07 W=2.5e-05
M57 VSSC 12 VDD VSSC n18pcesd L=2.5e-07 W=2.5e-05
M58 VDD 12 VSSC VSSC n18pcesd L=2.5e-07 W=2.5e-05
M59 VSSC 12 VDD VSSC n18pcesd L=2.5e-07 W=2.5e-05
M60 VDD 12 VSSC VSSC n18pcesd L=2.5e-07 W=2.5e-05
M61 VSSC 12 VDD VSSC n18pcesd L=2.5e-07 W=2.5e-05
M62 VDD 12 VSSC VSSC n18pcesd L=2.5e-07 W=2.5e-05
M63 VSSC 12 VDD VSSC n18pcesd L=2.5e-07 W=2.5e-05
M64 VDD 12 VSSC VSSC n18pcesd L=2.5e-07 W=2.5e-05
M65 VSSC 12 VDD VSSC n18pcesd L=2.5e-07 W=2.5e-05
M66 VDD 12 VSSC VSSC n18pcesd L=2.5e-07 W=2.5e-05
M67 VSSC 12 VDD VSSC n18pcesd L=2.5e-07 W=2.5e-05
M68 VDD 12 VSSC VSSC n18pcesd L=2.5e-07 W=2.5e-05
M69 VSSC 12 VDD VSSC n18pcesd L=2.5e-07 W=2.5e-05
M70 VDD 12 VSSC VSSC n18pcesd L=2.5e-07 W=2.5e-05
M71 VSSC 12 VDD VSSC n18pcesd L=2.5e-07 W=2.5e-05
M72 VDD 12 VSSC VSSC n18pcesd L=2.5e-07 W=2.5e-05
M73 VSSC 12 VDD VSSC n18pcesd L=2.5e-07 W=2.5e-05
M74 VDDO 7 VSSC VSSC n5pcesd L=6e-07 W=2.5e-05
M75 VSSC 7 VDDO VSSC n5pcesd L=6e-07 W=2.5e-05
M76 VDDO 7 VSSC VSSC n5pcesd L=6e-07 W=2.5e-05
M77 VSSC 7 VDDO VSSC n5pcesd L=6e-07 W=2.5e-05
M78 VDDO 7 VSSC VSSC n5pcesd L=6e-07 W=2.5e-05
M79 VSSC 7 VDDO VSSC n5pcesd L=6e-07 W=2.5e-05
M80 VDDO 7 VSSC VSSC n5pcesd L=6e-07 W=2.5e-05
M81 VSSC 7 VDDO VSSC n5pcesd L=6e-07 W=2.5e-05
M82 VDDO 7 VSSC VSSC n5pcesd L=6e-07 W=2.5e-05
M83 VSSC 7 VDDO VSSC n5pcesd L=6e-07 W=2.5e-05
M84 VDDO 7 VSSC VSSC n5pcesd L=6e-07 W=2.5e-05
M85 VSSC 7 VDDO VSSC n5pcesd L=6e-07 W=2.5e-05
M86 VDDO 7 VSSC VSSC n5pcesd L=6e-07 W=2.5e-05
M87 VSSC 7 VDDO VSSC n5pcesd L=6e-07 W=2.5e-05
M88 VDDO 7 VSSC VSSC n5pcesd L=6e-07 W=2.5e-05
M89 VSSC 7 VDDO VSSC n5pcesd L=6e-07 W=2.5e-05
M90 VDDO 7 VSSC VSSC n5pcesd L=6e-07 W=2.5e-05
M91 VSSC 7 VDDO VSSC n5pcesd L=6e-07 W=2.5e-05
M92 VDDO 7 VSSC VSSC n5pcesd L=6e-07 W=2.5e-05
M93 VSSC 7 VDDO VSSC n5pcesd L=6e-07 W=2.5e-05
M94 VDDC 9 VSSC VSSC n5pcesd L=6e-07 W=2.5e-05
M95 VSSC 9 VDDC VSSC n5pcesd L=6e-07 W=2.5e-05
M96 VDDC 9 VSSC VSSC n5pcesd L=6e-07 W=2.5e-05
M97 VSSC 9 VDDC VSSC n5pcesd L=6e-07 W=2.5e-05
M98 VDDC 9 VSSC VSSC n5pcesd L=6e-07 W=2.5e-05
M99 VSSC 9 VDDC VSSC n5pcesd L=6e-07 W=2.5e-05
M100 VDDC 9 VSSC VSSC n5pcesd L=6e-07 W=2.5e-05
M101 VSSC 9 VDDC VSSC n5pcesd L=6e-07 W=2.5e-05
M102 VDDC 9 VSSC VSSC n5pcesd L=6e-07 W=2.5e-05
M103 VSSC 9 VDDC VSSC n5pcesd L=6e-07 W=2.5e-05
M104 VDDC 9 VSSC VSSC n5pcesd L=6e-07 W=2.5e-05
M105 VSSC 9 VDDC VSSC n5pcesd L=6e-07 W=2.5e-05
M106 VDDC 9 VSSC VSSC n5pcesd L=6e-07 W=2.5e-05
M107 VSSC 9 VDDC VSSC n5pcesd L=6e-07 W=2.5e-05
M108 VDDC 9 VSSC VSSC n5pcesd L=6e-07 W=2.5e-05
M109 VSSC 9 VDDC VSSC n5pcesd L=6e-07 W=2.5e-05
M110 VDDC 9 VSSC VSSC n5pcesd L=6e-07 W=2.5e-05
M111 VSSC 9 VDDC VSSC n5pcesd L=6e-07 W=2.5e-05
M112 VDDC 9 VSSC VSSC n5pcesd L=6e-07 W=2.5e-05
M113 VSSC 9 VDDC VSSC n5pcesd L=6e-07 W=2.5e-05
D114 VSSO VSSC dpnwcpl5 AREA=1.642e-11 PJ=2.45314e-05 nf=1
D115 VSSO VSSC dpnwcpl5 AREA=1.642e-11 PJ=2.45314e-05 nf=1
D116 VSSO VSSC dpnwcpl5 AREA=1.642e-11 PJ=2.45314e-05 nf=1
D117 VSSO VSSC dpnwcpl5 AREA=1.642e-11 PJ=2.45314e-05 nf=1
D118 VSSO VSSC dpnwcpl5 AREA=1.642e-11 PJ=2.45314e-05 nf=1
D119 VSSO VSSC dpnwcpl5 AREA=1.642e-11 PJ=2.45314e-05 nf=1
D120 VSSO VSSC dpnwcpl5 AREA=1.642e-11 PJ=2.45314e-05 nf=1
D121 VSSO VSSC dpnwcpl5 AREA=1.642e-11 PJ=2.45314e-05 nf=1
D122 VSSO VSSC dpnwcpl5 AREA=1.642e-11 PJ=2.45314e-05 nf=1
D123 VSS VSSC dpnwcpl5 AREA=1.642e-11 PJ=2.45314e-05 nf=1
D124 VSS VSSC dpnwcpl5 AREA=1.642e-11 PJ=2.45314e-05 nf=1
D125 VSS VSSC dpnwcpl5 AREA=1.642e-11 PJ=2.45314e-05 nf=1
D126 VSS VSSC dpnwcpl5 AREA=1.642e-11 PJ=2.45314e-05 nf=1
D127 VSS VSSC dpnwcpl5 AREA=1.642e-11 PJ=2.45314e-05 nf=1
D128 VSS VSSC dpnwcpl5 AREA=1.642e-11 PJ=2.45314e-05 nf=1
D129 VSS VSSC dpnwcpl5 AREA=1.642e-11 PJ=2.45314e-05 nf=1
D130 VSS VSSC dpnwcpl5 AREA=1.642e-11 PJ=2.45314e-05 nf=1
D131 VSS VSSC dpnwcpl5 AREA=1.642e-11 PJ=2.45314e-05 nf=1
D132 VSSC VSSO dpnwcpl5 AREA=1.642e-11 PJ=2.45314e-05 nf=1
D133 VSSC VSSO dpnwcpl5 AREA=1.642e-11 PJ=2.45314e-05 nf=1
D134 VSSC VSSO dpnwcpl5 AREA=1.642e-11 PJ=2.45314e-05 nf=1
D135 VSSC VSSO dpnwcpl5 AREA=1.642e-11 PJ=2.45314e-05 nf=1
D136 VSSC VSSO dpnwcpl5 AREA=1.642e-11 PJ=2.45314e-05 nf=1
D137 VSSC VSSO dpnwcpl5 AREA=1.642e-11 PJ=2.45314e-05 nf=1
D138 VSSC VSSO dpnwcpl5 AREA=1.642e-11 PJ=2.45314e-05 nf=1
D139 VSSC VSSO dpnwcpl5 AREA=1.642e-11 PJ=2.45314e-05 nf=1
D140 VSSC VSSO dpnwcpl5 AREA=1.642e-11 PJ=2.45314e-05 nf=1
D141 VSSC VSS dpnwcpl5 AREA=1.642e-11 PJ=2.45314e-05 nf=1
D142 VSSC VSS dpnwcpl5 AREA=1.642e-11 PJ=2.45314e-05 nf=1
D143 VSSC VSS dpnwcpl5 AREA=1.642e-11 PJ=2.45314e-05 nf=1
D144 VSSC VSS dpnwcpl5 AREA=1.642e-11 PJ=2.45314e-05 nf=1
D145 VSSC VSS dpnwcpl5 AREA=1.642e-11 PJ=2.45314e-05 nf=1
D146 VSSC VSS dpnwcpl5 AREA=1.642e-11 PJ=2.45314e-05 nf=1
D147 VSSC VSS dpnwcpl5 AREA=1.642e-11 PJ=2.45314e-05 nf=1
D148 VSSC VSS dpnwcpl5 AREA=1.642e-11 PJ=2.45314e-05 nf=1
D149 VSSC VSS dpnwcpl5 AREA=1.642e-11 PJ=2.45314e-05 nf=1
.ENDS

.SUBCKT PV0C_50_50_50 VSSC VDDO VSSO VSS VDD VDDC
*.PININFO VSSC:B VDDO:B VSSO:B VSS:B VDD:B VDDC:B
M0 7 VDDO 7 VSSC N5 L=5e-06 W=5e-06 rf_flag=0
M1 7 VDDO 7 VSSC N5 L=5e-06 W=5e-06 rf_flag=0
M2 7 VDDO 7 VSSC N5 L=5e-06 W=5e-06 rf_flag=0
M3 7 VDDO 7 VSSC N5 L=5e-06 W=5e-06 rf_flag=0
M4 7 VDDO 7 VSSC N5 L=5e-06 W=5e-06 rf_flag=0
M5 7 VDDO 7 VSSC N5 L=5e-06 W=5e-06 rf_flag=0
M6 7 VDDO 7 VSSC N5 L=5e-06 W=5e-06 rf_flag=0
M7 7 VDDO 7 VSSC N5 L=5e-06 W=5e-06 rf_flag=0
M8 7 VDDO 7 VSSC N5 L=5e-06 W=5e-06 rf_flag=0
M9 7 VDDO 7 VSSC N5 L=5e-06 W=5e-06 rf_flag=0
M10 9 VDDC 9 VSSC N5 L=5e-06 W=5e-06 rf_flag=0
M11 9 VDDC 9 VSSC N5 L=5e-06 W=5e-06 rf_flag=0
M12 9 VDDC 9 VSSC N5 L=5e-06 W=5e-06 rf_flag=0
M13 9 VDDC 9 VSSC N5 L=5e-06 W=5e-06 rf_flag=0
M14 9 VDDC 9 VSSC N5 L=5e-06 W=5e-06 rf_flag=0
M15 9 VDDC 9 VSSC N5 L=5e-06 W=5e-06 rf_flag=0
M16 9 VDDC 9 VSSC N5 L=5e-06 W=5e-06 rf_flag=0
M17 9 VDDC 9 VSSC N5 L=5e-06 W=5e-06 rf_flag=0
M18 9 VDDC 9 VSSC N5 L=5e-06 W=5e-06 rf_flag=0
M19 9 VDDC 9 VSSC N5 L=5e-06 W=5e-06 rf_flag=0
M20 12 VDD 12 VSSC N5 L=5e-06 W=5e-06 rf_flag=0
M21 12 VDD 12 VSSC N5 L=5e-06 W=5e-06 rf_flag=0
M22 12 VDD 12 VSSC N5 L=5e-06 W=5e-06 rf_flag=0
M23 12 VDD 12 VSSC N5 L=5e-06 W=5e-06 rf_flag=0
M24 12 VDD 12 VSSC N5 L=5e-06 W=5e-06 rf_flag=0
M25 12 VDD 12 VSSC N5 L=5e-06 W=5e-06 rf_flag=0
M26 12 VDD 12 VSSC N5 L=5e-06 W=5e-06 rf_flag=0
M27 12 VDD 12 VSSC N5 L=5e-06 W=5e-06 rf_flag=0
M28 12 VDD 12 VSSC N5 L=5e-06 W=5e-06 rf_flag=0
M29 12 VDD 12 VSSC N5 L=5e-06 W=5e-06 rf_flag=0
R30 6 7 8325.14 L=4e-05 W=2e-06 postlayout=1 $SUB=VSSC $[RE3]
R31 8 9 8325.14 L=4e-05 W=2e-06 postlayout=1 $SUB=VSSC $[RE3]
R32 6 VSSC 8325.14 L=4e-05 W=2e-06 postlayout=1 $SUB=VSSC $[RE3]
R33 8 VSSC 8325.14 L=4e-05 W=2e-06 postlayout=1 $SUB=VSSC $[RE3]
R34 11 12 8325.14 L=4e-05 W=2e-06 postlayout=1 $SUB=VSSC $[RE3]
R35 11 VSSC 8325.14 L=4e-05 W=2e-06 postlayout=1 $SUB=VSSC $[RE3]
D36 VSS VDDO dwn2psub AREA=8.13573e-10 PJ=0.00080375
D37 VSS VDDC dwn2psub AREA=8.10766e-10 PJ=0.00080363
D38 VSSC VDDO dwn2psub AREA=8.13573e-10 PJ=0.00080375
D39 VSSC VDDC dwn2psub AREA=8.10766e-10 PJ=0.00080363
D40 VSSC VDDO dwn2psub AREA=8.13573e-10 PJ=0.00080375
D41 VSSC VDDC dwn2psub AREA=8.10766e-10 PJ=0.00080363
D42 VSS VDDO dwn2psub AREA=1.08515e-09 PJ=0.00086382
D43 VSS VDD dwn2psub AREA=8.13603e-10 PJ=0.00080378
D44 VSSO VDDO dwn2psub AREA=1.08515e-09 PJ=0.00086382
D45 VSS VDDO dwn2psub AREA=1.08515e-09 PJ=0.00086382
D46 VSSC VDD dwn2psub AREA=8.13603e-10 PJ=0.00080378
D47 VSSO VSSC dwn2psub AREA=6.3409e-10 PJ=0.00011544
D48 VSS VSSC dwn2psub AREA=6.3409e-10 PJ=0.00011544
D49 VSSC VDD dwn2psub AREA=8.13603e-10 PJ=0.00080378
D50 VSSO VDDO dwn2psub AREA=1.08515e-09 PJ=0.00086382
D51 VSS VDDO dwn2psub AREA=1.08515e-09 PJ=0.00086382
D52 VSSO VSSO dwn2psub AREA=6.3409e-10 PJ=0.00011544
D53 VSS VSS dwn2psub AREA=6.3409e-10 PJ=0.00011544
M54 VDDO 7 VSSC VSSC n5pcesd L=6e-07 W=2.5e-05
M55 VSSC 7 VDDO VSSC n5pcesd L=6e-07 W=2.5e-05
M56 VDDO 7 VSSC VSSC n5pcesd L=6e-07 W=2.5e-05
M57 VSSC 7 VDDO VSSC n5pcesd L=6e-07 W=2.5e-05
M58 VDDO 7 VSSC VSSC n5pcesd L=6e-07 W=2.5e-05
M59 VSSC 7 VDDO VSSC n5pcesd L=6e-07 W=2.5e-05
M60 VDDO 7 VSSC VSSC n5pcesd L=6e-07 W=2.5e-05
M61 VSSC 7 VDDO VSSC n5pcesd L=6e-07 W=2.5e-05
M62 VDDO 7 VSSC VSSC n5pcesd L=6e-07 W=2.5e-05
M63 VSSC 7 VDDO VSSC n5pcesd L=6e-07 W=2.5e-05
M64 VDDO 7 VSSC VSSC n5pcesd L=6e-07 W=2.5e-05
M65 VSSC 7 VDDO VSSC n5pcesd L=6e-07 W=2.5e-05
M66 VDDO 7 VSSC VSSC n5pcesd L=6e-07 W=2.5e-05
M67 VSSC 7 VDDO VSSC n5pcesd L=6e-07 W=2.5e-05
M68 VDDO 7 VSSC VSSC n5pcesd L=6e-07 W=2.5e-05
M69 VSSC 7 VDDO VSSC n5pcesd L=6e-07 W=2.5e-05
M70 VDDO 7 VSSC VSSC n5pcesd L=6e-07 W=2.5e-05
M71 VSSC 7 VDDO VSSC n5pcesd L=6e-07 W=2.5e-05
M72 VDDO 7 VSSC VSSC n5pcesd L=6e-07 W=2.5e-05
M73 VSSC 7 VDDO VSSC n5pcesd L=6e-07 W=2.5e-05
M74 VDDC 9 VSSC VSSC n5pcesd L=6e-07 W=2.5e-05
M75 VSSC 9 VDDC VSSC n5pcesd L=6e-07 W=2.5e-05
M76 VDDC 9 VSSC VSSC n5pcesd L=6e-07 W=2.5e-05
M77 VSSC 9 VDDC VSSC n5pcesd L=6e-07 W=2.5e-05
M78 VDDC 9 VSSC VSSC n5pcesd L=6e-07 W=2.5e-05
M79 VSSC 9 VDDC VSSC n5pcesd L=6e-07 W=2.5e-05
M80 VDDC 9 VSSC VSSC n5pcesd L=6e-07 W=2.5e-05
M81 VSSC 9 VDDC VSSC n5pcesd L=6e-07 W=2.5e-05
M82 VDDC 9 VSSC VSSC n5pcesd L=6e-07 W=2.5e-05
M83 VSSC 9 VDDC VSSC n5pcesd L=6e-07 W=2.5e-05
M84 VDDC 9 VSSC VSSC n5pcesd L=6e-07 W=2.5e-05
M85 VSSC 9 VDDC VSSC n5pcesd L=6e-07 W=2.5e-05
M86 VDDC 9 VSSC VSSC n5pcesd L=6e-07 W=2.5e-05
M87 VSSC 9 VDDC VSSC n5pcesd L=6e-07 W=2.5e-05
M88 VDDC 9 VSSC VSSC n5pcesd L=6e-07 W=2.5e-05
M89 VSSC 9 VDDC VSSC n5pcesd L=6e-07 W=2.5e-05
M90 VDDC 9 VSSC VSSC n5pcesd L=6e-07 W=2.5e-05
M91 VSSC 9 VDDC VSSC n5pcesd L=6e-07 W=2.5e-05
M92 VDDC 9 VSSC VSSC n5pcesd L=6e-07 W=2.5e-05
M93 VSSC 9 VDDC VSSC n5pcesd L=6e-07 W=2.5e-05
M94 VDD 12 VSSC VSSC n5pcesd L=6e-07 W=2.5e-05
M95 VSSC 12 VDD VSSC n5pcesd L=6e-07 W=2.5e-05
M96 VDD 12 VSSC VSSC n5pcesd L=6e-07 W=2.5e-05
M97 VSSC 12 VDD VSSC n5pcesd L=6e-07 W=2.5e-05
M98 VDD 12 VSSC VSSC n5pcesd L=6e-07 W=2.5e-05
M99 VSSC 12 VDD VSSC n5pcesd L=6e-07 W=2.5e-05
M100 VDD 12 VSSC VSSC n5pcesd L=6e-07 W=2.5e-05
M101 VSSC 12 VDD VSSC n5pcesd L=6e-07 W=2.5e-05
M102 VDD 12 VSSC VSSC n5pcesd L=6e-07 W=2.5e-05
M103 VSSC 12 VDD VSSC n5pcesd L=6e-07 W=2.5e-05
M104 VDD 12 VSSC VSSC n5pcesd L=6e-07 W=2.5e-05
M105 VSSC 12 VDD VSSC n5pcesd L=6e-07 W=2.5e-05
M106 VDD 12 VSSC VSSC n5pcesd L=6e-07 W=2.5e-05
M107 VSSC 12 VDD VSSC n5pcesd L=6e-07 W=2.5e-05
M108 VDD 12 VSSC VSSC n5pcesd L=6e-07 W=2.5e-05
M109 VSSC 12 VDD VSSC n5pcesd L=6e-07 W=2.5e-05
M110 VDD 12 VSSC VSSC n5pcesd L=6e-07 W=2.5e-05
M111 VSSC 12 VDD VSSC n5pcesd L=6e-07 W=2.5e-05
M112 VDD 12 VSSC VSSC n5pcesd L=6e-07 W=2.5e-05
M113 VSSC 12 VDD VSSC n5pcesd L=6e-07 W=2.5e-05
D114 VSSO VSSC dpnwcpl5 AREA=1.642e-11 PJ=2.45314e-05 nf=1
D115 VSSO VSSC dpnwcpl5 AREA=1.642e-11 PJ=2.45314e-05 nf=1
D116 VSSO VSSC dpnwcpl5 AREA=1.642e-11 PJ=2.45314e-05 nf=1
D117 VSSO VSSC dpnwcpl5 AREA=1.642e-11 PJ=2.45314e-05 nf=1
D118 VSSO VSSC dpnwcpl5 AREA=1.642e-11 PJ=2.45314e-05 nf=1
D119 VSSO VSSC dpnwcpl5 AREA=1.642e-11 PJ=2.45314e-05 nf=1
D120 VSSO VSSC dpnwcpl5 AREA=1.642e-11 PJ=2.45314e-05 nf=1
D121 VSSO VSSC dpnwcpl5 AREA=1.642e-11 PJ=2.45314e-05 nf=1
D122 VSSO VSSC dpnwcpl5 AREA=1.642e-11 PJ=2.45314e-05 nf=1
D123 VSS VSSC dpnwcpl5 AREA=1.642e-11 PJ=2.45314e-05 nf=1
D124 VSS VSSC dpnwcpl5 AREA=1.642e-11 PJ=2.45314e-05 nf=1
D125 VSS VSSC dpnwcpl5 AREA=1.642e-11 PJ=2.45314e-05 nf=1
D126 VSS VSSC dpnwcpl5 AREA=1.642e-11 PJ=2.45314e-05 nf=1
D127 VSS VSSC dpnwcpl5 AREA=1.642e-11 PJ=2.45314e-05 nf=1
D128 VSS VSSC dpnwcpl5 AREA=1.642e-11 PJ=2.45314e-05 nf=1
D129 VSS VSSC dpnwcpl5 AREA=1.642e-11 PJ=2.45314e-05 nf=1
D130 VSS VSSC dpnwcpl5 AREA=1.642e-11 PJ=2.45314e-05 nf=1
D131 VSS VSSC dpnwcpl5 AREA=1.642e-11 PJ=2.45314e-05 nf=1
D132 VSSC VSSO dpnwcpl5 AREA=1.642e-11 PJ=2.45314e-05 nf=1
D133 VSSC VSSO dpnwcpl5 AREA=1.642e-11 PJ=2.45314e-05 nf=1
D134 VSSC VSSO dpnwcpl5 AREA=1.642e-11 PJ=2.45314e-05 nf=1
D135 VSSC VSSO dpnwcpl5 AREA=1.642e-11 PJ=2.45314e-05 nf=1
D136 VSSC VSSO dpnwcpl5 AREA=1.642e-11 PJ=2.45314e-05 nf=1
D137 VSSC VSSO dpnwcpl5 AREA=1.642e-11 PJ=2.45314e-05 nf=1
D138 VSSC VSSO dpnwcpl5 AREA=1.642e-11 PJ=2.45314e-05 nf=1
D139 VSSC VSSO dpnwcpl5 AREA=1.642e-11 PJ=2.45314e-05 nf=1
D140 VSSC VSSO dpnwcpl5 AREA=1.642e-11 PJ=2.45314e-05 nf=1
D141 VSSC VSS dpnwcpl5 AREA=1.642e-11 PJ=2.45314e-05 nf=1
D142 VSSC VSS dpnwcpl5 AREA=1.642e-11 PJ=2.45314e-05 nf=1
D143 VSSC VSS dpnwcpl5 AREA=1.642e-11 PJ=2.45314e-05 nf=1
D144 VSSC VSS dpnwcpl5 AREA=1.642e-11 PJ=2.45314e-05 nf=1
D145 VSSC VSS dpnwcpl5 AREA=1.642e-11 PJ=2.45314e-05 nf=1
D146 VSSC VSS dpnwcpl5 AREA=1.642e-11 PJ=2.45314e-05 nf=1
D147 VSSC VSS dpnwcpl5 AREA=1.642e-11 PJ=2.45314e-05 nf=1
D148 VSSC VSS dpnwcpl5 AREA=1.642e-11 PJ=2.45314e-05 nf=1
D149 VSSC VSS dpnwcpl5 AREA=1.642e-11 PJ=2.45314e-05 nf=1
.ENDS

.SUBCKT PV0F_18_18 VSSO VDDO VDD VSS
*.PININFO VSSO:B VDDO:B VDD:B VSS:B
M0 6 VDDO 6 VSSO N L=5e-06 W=5e-06 rf_flag=0
M1 6 VDDO 6 VSSO N L=5e-06 W=5e-06 rf_flag=0
M2 6 VDDO 6 VSSO N L=5e-06 W=5e-06 rf_flag=0
M3 6 VDDO 6 VSSO N L=5e-06 W=5e-06 rf_flag=0
M4 6 VDDO 6 VSSO N L=5e-06 W=5e-06 rf_flag=0
M5 6 VDDO 6 VSSO N L=5e-06 W=5e-06 rf_flag=0
M6 6 VDDO 6 VSSO N L=5e-06 W=5e-06 rf_flag=0
M7 6 VDDO 6 VSSO N L=5e-06 W=5e-06 rf_flag=0
M8 6 VDDO 6 VSSO N L=5e-06 W=5e-06 rf_flag=0
M9 6 VDDO 6 VSSO N L=5e-06 W=5e-06 rf_flag=0
M10 7 VDD 7 VSSO N L=5e-06 W=5e-06 rf_flag=0
M11 7 VDD 7 VSSO N L=5e-06 W=5e-06 rf_flag=0
M12 7 VDD 7 VSSO N L=5e-06 W=5e-06 rf_flag=0
M13 7 VDD 7 VSSO N L=5e-06 W=5e-06 rf_flag=0
M14 7 VDD 7 VSSO N L=5e-06 W=5e-06 rf_flag=0
M15 7 VDD 7 VSSO N L=5e-06 W=5e-06 rf_flag=0
M16 7 VDD 7 VSSO N L=5e-06 W=5e-06 rf_flag=0
M17 7 VDD 7 VSSO N L=5e-06 W=5e-06 rf_flag=0
M18 7 VDD 7 VSSO N L=5e-06 W=5e-06 rf_flag=0
M19 7 VDD 7 VSSO N L=5e-06 W=5e-06 rf_flag=0
R20 4 VSSO 8325.14 L=4e-05 W=2e-06 postlayout=1 $SUB=VSSO $[RE3]
R21 5 VSSO 8325.14 L=4e-05 W=2e-06 postlayout=1 $SUB=VSSO $[RE3]
R22 4 6 8325.14 L=4e-05 W=2e-06 postlayout=1 $SUB=VSSO $[RE3]
R23 5 7 8325.14 L=4e-05 W=2e-06 postlayout=1 $SUB=VSSO $[RE3]
D24 VSSO VDDO dwn2psub AREA=8.1234e-10 PJ=0.00080834
D25 VSSO VDD dwn2psub AREA=8.1234e-10 PJ=0.00080834
D26 VSSO VDDO dwn2psub AREA=8.1234e-10 PJ=0.00080834
D27 VSSO VDD dwn2psub AREA=8.1234e-10 PJ=0.00080834
D28 VSSO VDDO dwn2psub AREA=8.1234e-10 PJ=0.00080834
D29 VSSO VDD dwn2psub AREA=8.1234e-10 PJ=0.00080834
M30 VDDO 6 VSSO VSSO n18pcesd L=2.5e-07 W=2.5e-05
M31 VSSO 6 VDDO VSSO n18pcesd L=2.5e-07 W=2.5e-05
M32 VDDO 6 VSSO VSSO n18pcesd L=2.5e-07 W=2.5e-05
M33 VSSO 6 VDDO VSSO n18pcesd L=2.5e-07 W=2.5e-05
M34 VDDO 6 VSSO VSSO n18pcesd L=2.5e-07 W=2.5e-05
M35 VSSO 6 VDDO VSSO n18pcesd L=2.5e-07 W=2.5e-05
M36 VDDO 6 VSSO VSSO n18pcesd L=2.5e-07 W=2.5e-05
M37 VSSO 6 VDDO VSSO n18pcesd L=2.5e-07 W=2.5e-05
M38 VDDO 6 VSSO VSSO n18pcesd L=2.5e-07 W=2.5e-05
M39 VSSO 6 VDDO VSSO n18pcesd L=2.5e-07 W=2.5e-05
M40 VDDO 6 VSSO VSSO n18pcesd L=2.5e-07 W=2.5e-05
M41 VSSO 6 VDDO VSSO n18pcesd L=2.5e-07 W=2.5e-05
M42 VDDO 6 VSSO VSSO n18pcesd L=2.5e-07 W=2.5e-05
M43 VSSO 6 VDDO VSSO n18pcesd L=2.5e-07 W=2.5e-05
M44 VDDO 6 VSSO VSSO n18pcesd L=2.5e-07 W=2.5e-05
M45 VSSO 6 VDDO VSSO n18pcesd L=2.5e-07 W=2.5e-05
M46 VDDO 6 VSSO VSSO n18pcesd L=2.5e-07 W=2.5e-05
M47 VSSO 6 VDDO VSSO n18pcesd L=2.5e-07 W=2.5e-05
M48 VDDO 6 VSSO VSSO n18pcesd L=2.5e-07 W=2.5e-05
M49 VSSO 6 VDDO VSSO n18pcesd L=2.5e-07 W=2.5e-05
M50 VDD 7 VSSO VSSO n18pcesd L=2.5e-07 W=2.5e-05
M51 VSSO 7 VDD VSSO n18pcesd L=2.5e-07 W=2.5e-05
M52 VDD 7 VSSO VSSO n18pcesd L=2.5e-07 W=2.5e-05
M53 VSSO 7 VDD VSSO n18pcesd L=2.5e-07 W=2.5e-05
M54 VDD 7 VSSO VSSO n18pcesd L=2.5e-07 W=2.5e-05
M55 VSSO 7 VDD VSSO n18pcesd L=2.5e-07 W=2.5e-05
M56 VDD 7 VSSO VSSO n18pcesd L=2.5e-07 W=2.5e-05
M57 VSSO 7 VDD VSSO n18pcesd L=2.5e-07 W=2.5e-05
M58 VDD 7 VSSO VSSO n18pcesd L=2.5e-07 W=2.5e-05
M59 VSSO 7 VDD VSSO n18pcesd L=2.5e-07 W=2.5e-05
M60 VDD 7 VSSO VSSO n18pcesd L=2.5e-07 W=2.5e-05
M61 VSSO 7 VDD VSSO n18pcesd L=2.5e-07 W=2.5e-05
M62 VDD 7 VSSO VSSO n18pcesd L=2.5e-07 W=2.5e-05
M63 VSSO 7 VDD VSSO n18pcesd L=2.5e-07 W=2.5e-05
M64 VDD 7 VSSO VSSO n18pcesd L=2.5e-07 W=2.5e-05
M65 VSSO 7 VDD VSSO n18pcesd L=2.5e-07 W=2.5e-05
M66 VDD 7 VSSO VSSO n18pcesd L=2.5e-07 W=2.5e-05
M67 VSSO 7 VDD VSSO n18pcesd L=2.5e-07 W=2.5e-05
M68 VDD 7 VSSO VSSO n18pcesd L=2.5e-07 W=2.5e-05
M69 VSSO 7 VDD VSSO n18pcesd L=2.5e-07 W=2.5e-05
.ENDS

.SUBCKT PV0F_50_18 VSSO VDDO VDD VSS
*.PININFO VSSO:B VDDO:B VDD:B VSS:B
M0 6 VDDO 6 VSSO N5 L=5e-06 W=5e-06 rf_flag=0
M1 6 VDDO 6 VSSO N5 L=5e-06 W=5e-06 rf_flag=0
M2 6 VDDO 6 VSSO N5 L=5e-06 W=5e-06 rf_flag=0
M3 6 VDDO 6 VSSO N5 L=5e-06 W=5e-06 rf_flag=0
M4 6 VDDO 6 VSSO N5 L=5e-06 W=5e-06 rf_flag=0
M5 6 VDDO 6 VSSO N5 L=5e-06 W=5e-06 rf_flag=0
M6 6 VDDO 6 VSSO N5 L=5e-06 W=5e-06 rf_flag=0
M7 6 VDDO 6 VSSO N5 L=5e-06 W=5e-06 rf_flag=0
M8 6 VDDO 6 VSSO N5 L=5e-06 W=5e-06 rf_flag=0
M9 6 VDDO 6 VSSO N5 L=5e-06 W=5e-06 rf_flag=0
M10 7 VDD 7 VSSO N L=5e-06 W=5e-06 rf_flag=0
M11 7 VDD 7 VSSO N L=5e-06 W=5e-06 rf_flag=0
M12 7 VDD 7 VSSO N L=5e-06 W=5e-06 rf_flag=0
M13 7 VDD 7 VSSO N L=5e-06 W=5e-06 rf_flag=0
M14 7 VDD 7 VSSO N L=5e-06 W=5e-06 rf_flag=0
M15 7 VDD 7 VSSO N L=5e-06 W=5e-06 rf_flag=0
M16 7 VDD 7 VSSO N L=5e-06 W=5e-06 rf_flag=0
M17 7 VDD 7 VSSO N L=5e-06 W=5e-06 rf_flag=0
M18 7 VDD 7 VSSO N L=5e-06 W=5e-06 rf_flag=0
M19 7 VDD 7 VSSO N L=5e-06 W=5e-06 rf_flag=0
R20 4 VSSO 8325.14 L=4e-05 W=2e-06 postlayout=1 $SUB=VSSO $[RE3]
R21 5 VSSO 8325.14 L=4e-05 W=2e-06 postlayout=1 $SUB=VSSO $[RE3]
R22 4 6 8325.14 L=4e-05 W=2e-06 postlayout=1 $SUB=VSSO $[RE3]
R23 5 7 8325.14 L=4e-05 W=2e-06 postlayout=1 $SUB=VSSO $[RE3]
D24 VSSO VDDO dwn2psub AREA=8.1234e-10 PJ=0.00080834
D25 VSSO VDD dwn2psub AREA=8.1234e-10 PJ=0.00080834
D26 VSSO VDDO dwn2psub AREA=8.1234e-10 PJ=0.00080834
D27 VSSO VDD dwn2psub AREA=8.1234e-10 PJ=0.00080834
D28 VSSO VDDO dwn2psub AREA=8.1234e-10 PJ=0.00080834
D29 VSSO VDD dwn2psub AREA=8.1234e-10 PJ=0.00080834
M30 VDD 7 VSSO VSSO n18pcesd L=2.5e-07 W=2.5e-05
M31 VSSO 7 VDD VSSO n18pcesd L=2.5e-07 W=2.5e-05
M32 VDD 7 VSSO VSSO n18pcesd L=2.5e-07 W=2.5e-05
M33 VSSO 7 VDD VSSO n18pcesd L=2.5e-07 W=2.5e-05
M34 VDD 7 VSSO VSSO n18pcesd L=2.5e-07 W=2.5e-05
M35 VSSO 7 VDD VSSO n18pcesd L=2.5e-07 W=2.5e-05
M36 VDD 7 VSSO VSSO n18pcesd L=2.5e-07 W=2.5e-05
M37 VSSO 7 VDD VSSO n18pcesd L=2.5e-07 W=2.5e-05
M38 VDD 7 VSSO VSSO n18pcesd L=2.5e-07 W=2.5e-05
M39 VSSO 7 VDD VSSO n18pcesd L=2.5e-07 W=2.5e-05
M40 VDD 7 VSSO VSSO n18pcesd L=2.5e-07 W=2.5e-05
M41 VSSO 7 VDD VSSO n18pcesd L=2.5e-07 W=2.5e-05
M42 VDD 7 VSSO VSSO n18pcesd L=2.5e-07 W=2.5e-05
M43 VSSO 7 VDD VSSO n18pcesd L=2.5e-07 W=2.5e-05
M44 VDD 7 VSSO VSSO n18pcesd L=2.5e-07 W=2.5e-05
M45 VSSO 7 VDD VSSO n18pcesd L=2.5e-07 W=2.5e-05
M46 VDD 7 VSSO VSSO n18pcesd L=2.5e-07 W=2.5e-05
M47 VSSO 7 VDD VSSO n18pcesd L=2.5e-07 W=2.5e-05
M48 VDD 7 VSSO VSSO n18pcesd L=2.5e-07 W=2.5e-05
M49 VSSO 7 VDD VSSO n18pcesd L=2.5e-07 W=2.5e-05
M50 VDDO 6 VSSO VSSO n5pcesd L=6e-07 W=2.5e-05
M51 VSSO 6 VDDO VSSO n5pcesd L=6e-07 W=2.5e-05
M52 VDDO 6 VSSO VSSO n5pcesd L=6e-07 W=2.5e-05
M53 VSSO 6 VDDO VSSO n5pcesd L=6e-07 W=2.5e-05
M54 VDDO 6 VSSO VSSO n5pcesd L=6e-07 W=2.5e-05
M55 VSSO 6 VDDO VSSO n5pcesd L=6e-07 W=2.5e-05
M56 VDDO 6 VSSO VSSO n5pcesd L=6e-07 W=2.5e-05
M57 VSSO 6 VDDO VSSO n5pcesd L=6e-07 W=2.5e-05
M58 VDDO 6 VSSO VSSO n5pcesd L=6e-07 W=2.5e-05
M59 VSSO 6 VDDO VSSO n5pcesd L=6e-07 W=2.5e-05
M60 VDDO 6 VSSO VSSO n5pcesd L=6e-07 W=2.5e-05
M61 VSSO 6 VDDO VSSO n5pcesd L=6e-07 W=2.5e-05
M62 VDDO 6 VSSO VSSO n5pcesd L=6e-07 W=2.5e-05
M63 VSSO 6 VDDO VSSO n5pcesd L=6e-07 W=2.5e-05
M64 VDDO 6 VSSO VSSO n5pcesd L=6e-07 W=2.5e-05
M65 VSSO 6 VDDO VSSO n5pcesd L=6e-07 W=2.5e-05
M66 VDDO 6 VSSO VSSO n5pcesd L=6e-07 W=2.5e-05
M67 VSSO 6 VDDO VSSO n5pcesd L=6e-07 W=2.5e-05
M68 VDDO 6 VSSO VSSO n5pcesd L=6e-07 W=2.5e-05
M69 VSSO 6 VDDO VSSO n5pcesd L=6e-07 W=2.5e-05
.ENDS

.SUBCKT PV0F_50_50 VSSO VDDO VDD VSS
*.PININFO VSSO:B VDDO:B VDD:B VSS:B
M0 6 VDDO 6 VSSO N5 L=5e-06 W=5e-06 rf_flag=0
M1 6 VDDO 6 VSSO N5 L=5e-06 W=5e-06 rf_flag=0
M2 6 VDDO 6 VSSO N5 L=5e-06 W=5e-06 rf_flag=0
M3 6 VDDO 6 VSSO N5 L=5e-06 W=5e-06 rf_flag=0
M4 6 VDDO 6 VSSO N5 L=5e-06 W=5e-06 rf_flag=0
M5 6 VDDO 6 VSSO N5 L=5e-06 W=5e-06 rf_flag=0
M6 6 VDDO 6 VSSO N5 L=5e-06 W=5e-06 rf_flag=0
M7 6 VDDO 6 VSSO N5 L=5e-06 W=5e-06 rf_flag=0
M8 6 VDDO 6 VSSO N5 L=5e-06 W=5e-06 rf_flag=0
M9 6 VDDO 6 VSSO N5 L=5e-06 W=5e-06 rf_flag=0
M10 7 VDD 7 VSSO N5 L=5e-06 W=5e-06 rf_flag=0
M11 7 VDD 7 VSSO N5 L=5e-06 W=5e-06 rf_flag=0
M12 7 VDD 7 VSSO N5 L=5e-06 W=5e-06 rf_flag=0
M13 7 VDD 7 VSSO N5 L=5e-06 W=5e-06 rf_flag=0
M14 7 VDD 7 VSSO N5 L=5e-06 W=5e-06 rf_flag=0
M15 7 VDD 7 VSSO N5 L=5e-06 W=5e-06 rf_flag=0
M16 7 VDD 7 VSSO N5 L=5e-06 W=5e-06 rf_flag=0
M17 7 VDD 7 VSSO N5 L=5e-06 W=5e-06 rf_flag=0
M18 7 VDD 7 VSSO N5 L=5e-06 W=5e-06 rf_flag=0
M19 7 VDD 7 VSSO N5 L=5e-06 W=5e-06 rf_flag=0
R20 4 VSSO 8325.14 L=4e-05 W=2e-06 postlayout=1 $SUB=VSSO $[RE3]
R21 5 VSSO 8325.14 L=4e-05 W=2e-06 postlayout=1 $SUB=VSSO $[RE3]
R22 4 6 8325.14 L=4e-05 W=2e-06 postlayout=1 $SUB=VSSO $[RE3]
R23 5 7 8325.14 L=4e-05 W=2e-06 postlayout=1 $SUB=VSSO $[RE3]
D24 VSSO VDDO dwn2psub AREA=8.1234e-10 PJ=0.00080834
D25 VSSO VDD dwn2psub AREA=8.1234e-10 PJ=0.00080834
D26 VSSO VDDO dwn2psub AREA=8.1234e-10 PJ=0.00080834
D27 VSSO VDD dwn2psub AREA=8.1234e-10 PJ=0.00080834
D28 VSSO VDDO dwn2psub AREA=8.1234e-10 PJ=0.00080834
D29 VSSO VDD dwn2psub AREA=8.1234e-10 PJ=0.00080834
M30 VDDO 6 VSSO VSSO n5pcesd L=6e-07 W=2.5e-05
M31 VSSO 6 VDDO VSSO n5pcesd L=6e-07 W=2.5e-05
M32 VDDO 6 VSSO VSSO n5pcesd L=6e-07 W=2.5e-05
M33 VSSO 6 VDDO VSSO n5pcesd L=6e-07 W=2.5e-05
M34 VDDO 6 VSSO VSSO n5pcesd L=6e-07 W=2.5e-05
M35 VSSO 6 VDDO VSSO n5pcesd L=6e-07 W=2.5e-05
M36 VDDO 6 VSSO VSSO n5pcesd L=6e-07 W=2.5e-05
M37 VSSO 6 VDDO VSSO n5pcesd L=6e-07 W=2.5e-05
M38 VDDO 6 VSSO VSSO n5pcesd L=6e-07 W=2.5e-05
M39 VSSO 6 VDDO VSSO n5pcesd L=6e-07 W=2.5e-05
M40 VDDO 6 VSSO VSSO n5pcesd L=6e-07 W=2.5e-05
M41 VSSO 6 VDDO VSSO n5pcesd L=6e-07 W=2.5e-05
M42 VDDO 6 VSSO VSSO n5pcesd L=6e-07 W=2.5e-05
M43 VSSO 6 VDDO VSSO n5pcesd L=6e-07 W=2.5e-05
M44 VDDO 6 VSSO VSSO n5pcesd L=6e-07 W=2.5e-05
M45 VSSO 6 VDDO VSSO n5pcesd L=6e-07 W=2.5e-05
M46 VDDO 6 VSSO VSSO n5pcesd L=6e-07 W=2.5e-05
M47 VSSO 6 VDDO VSSO n5pcesd L=6e-07 W=2.5e-05
M48 VDDO 6 VSSO VSSO n5pcesd L=6e-07 W=2.5e-05
M49 VSSO 6 VDDO VSSO n5pcesd L=6e-07 W=2.5e-05
M50 VDD 7 VSSO VSSO n5pcesd L=6e-07 W=2.5e-05
M51 VSSO 7 VDD VSSO n5pcesd L=6e-07 W=2.5e-05
M52 VDD 7 VSSO VSSO n5pcesd L=6e-07 W=2.5e-05
M53 VSSO 7 VDD VSSO n5pcesd L=6e-07 W=2.5e-05
M54 VDD 7 VSSO VSSO n5pcesd L=6e-07 W=2.5e-05
M55 VSSO 7 VDD VSSO n5pcesd L=6e-07 W=2.5e-05
M56 VDD 7 VSSO VSSO n5pcesd L=6e-07 W=2.5e-05
M57 VSSO 7 VDD VSSO n5pcesd L=6e-07 W=2.5e-05
M58 VDD 7 VSSO VSSO n5pcesd L=6e-07 W=2.5e-05
M59 VSSO 7 VDD VSSO n5pcesd L=6e-07 W=2.5e-05
M60 VDD 7 VSSO VSSO n5pcesd L=6e-07 W=2.5e-05
M61 VSSO 7 VDD VSSO n5pcesd L=6e-07 W=2.5e-05
M62 VDD 7 VSSO VSSO n5pcesd L=6e-07 W=2.5e-05
M63 VSSO 7 VDD VSSO n5pcesd L=6e-07 W=2.5e-05
M64 VDD 7 VSSO VSSO n5pcesd L=6e-07 W=2.5e-05
M65 VSSO 7 VDD VSSO n5pcesd L=6e-07 W=2.5e-05
M66 VDD 7 VSSO VSSO n5pcesd L=6e-07 W=2.5e-05
M67 VSSO 7 VDD VSSO n5pcesd L=6e-07 W=2.5e-05
M68 VDD 7 VSSO VSSO n5pcesd L=6e-07 W=2.5e-05
M69 VSSO 7 VDD VSSO n5pcesd L=6e-07 W=2.5e-05
.ENDS

.SUBCKT PV0I_18_18 VSS VDDO VSSO VDD
*.PININFO VSS:B VDDO:B VSSO:B VDD:B
M0 7 VDDO 7 VSS N L=4.55e-06 W=5.5e-06 rf_flag=0
M1 7 VDDO 7 VSS N L=4.55e-06 W=5.5e-06 rf_flag=0
M2 7 VDDO 7 VSS N L=4.55e-06 W=5.5e-06 rf_flag=0
M3 7 VDDO 7 VSS N L=4.55e-06 W=5.5e-06 rf_flag=0
M4 7 VDDO 7 VSS N L=4.55e-06 W=5.5e-06 rf_flag=0
M5 7 VDDO 7 VSS N L=4.55e-06 W=5.5e-06 rf_flag=0
M6 7 VDDO 7 VSS N L=4.55e-06 W=5.5e-06 rf_flag=0
M7 7 VDDO 7 VSS N L=4.55e-06 W=5.5e-06 rf_flag=0
M8 7 VDDO 7 VSS N L=4.55e-06 W=5.5e-06 rf_flag=0
M9 7 VDDO 7 VSS N L=4.55e-06 W=5.5e-06 rf_flag=0
M10 8 VDD 8 VSS N L=4.55e-06 W=5.5e-06 rf_flag=0
M11 8 VDD 8 VSS N L=4.55e-06 W=5.5e-06 rf_flag=0
M12 8 VDD 8 VSS N L=4.55e-06 W=5.5e-06 rf_flag=0
M13 8 VDD 8 VSS N L=4.55e-06 W=5.5e-06 rf_flag=0
M14 8 VDD 8 VSS N L=4.55e-06 W=5.5e-06 rf_flag=0
M15 8 VDD 8 VSS N L=4.55e-06 W=5.5e-06 rf_flag=0
M16 8 VDD 8 VSS N L=4.55e-06 W=5.5e-06 rf_flag=0
M17 8 VDD 8 VSS N L=4.55e-06 W=5.5e-06 rf_flag=0
M18 8 VDD 8 VSS N L=4.55e-06 W=5.5e-06 rf_flag=0
M19 8 VDD 8 VSS N L=4.55e-06 W=5.5e-06 rf_flag=0
R20 5 VSS 8325.14 L=4e-05 W=2e-06 postlayout=1 $SUB=VSS $[RE3]
R21 6 VSS 8325.14 L=4e-05 W=2e-06 postlayout=1 $SUB=VSS $[RE3]
R22 5 7 8325.14 L=4e-05 W=2e-06 postlayout=1 $SUB=VSS $[RE3]
R23 6 8 8325.14 L=4e-05 W=2e-06 postlayout=1 $SUB=VSS $[RE3]
D24 VSS VDDO dwn2psub AREA=8.1828e-10 PJ=0.00081428
D25 VSS VDD dwn2psub AREA=8.1828e-10 PJ=0.00081428
D26 VSS VDDO dwn2psub AREA=8.1828e-10 PJ=0.00081428
D27 VSS VDD dwn2psub AREA=8.1828e-10 PJ=0.00081428
D28 VSS VDDO dwn2psub AREA=8.1828e-10 PJ=0.00081428
D29 VSS VDD dwn2psub AREA=8.1828e-10 PJ=0.00081428
D30 VSS VDDO dwn2psub AREA=4.957e-10 PJ=0.0004917
D31 VSS VDDO dwn2psub AREA=4.957e-10 PJ=0.0004917
D32 VSSO VDDO dwn2psub AREA=4.957e-10 PJ=0.0004917
D33 VSS VSS dwn2psub AREA=6.3709e-10 PJ=0.00010544
D34 VSSO VSSO dwn2psub AREA=6.3709e-10 PJ=0.00010544
M35 VDDO 7 VSS VSS n18pcesd L=2.5e-07 W=2.5e-05
M36 VSS 7 VDDO VSS n18pcesd L=2.5e-07 W=2.5e-05
M37 VDDO 7 VSS VSS n18pcesd L=2.5e-07 W=2.5e-05
M38 VSS 7 VDDO VSS n18pcesd L=2.5e-07 W=2.5e-05
M39 VDDO 7 VSS VSS n18pcesd L=2.5e-07 W=2.5e-05
M40 VSS 7 VDDO VSS n18pcesd L=2.5e-07 W=2.5e-05
M41 VDDO 7 VSS VSS n18pcesd L=2.5e-07 W=2.5e-05
M42 VSS 7 VDDO VSS n18pcesd L=2.5e-07 W=2.5e-05
M43 VDDO 7 VSS VSS n18pcesd L=2.5e-07 W=2.5e-05
M44 VSS 7 VDDO VSS n18pcesd L=2.5e-07 W=2.5e-05
M45 VDDO 7 VSS VSS n18pcesd L=2.5e-07 W=2.5e-05
M46 VSS 7 VDDO VSS n18pcesd L=2.5e-07 W=2.5e-05
M47 VDDO 7 VSS VSS n18pcesd L=2.5e-07 W=2.5e-05
M48 VSS 7 VDDO VSS n18pcesd L=2.5e-07 W=2.5e-05
M49 VDDO 7 VSS VSS n18pcesd L=2.5e-07 W=2.5e-05
M50 VSS 7 VDDO VSS n18pcesd L=2.5e-07 W=2.5e-05
M51 VDDO 7 VSS VSS n18pcesd L=2.5e-07 W=2.5e-05
M52 VSS 7 VDDO VSS n18pcesd L=2.5e-07 W=2.5e-05
M53 VDDO 7 VSS VSS n18pcesd L=2.5e-07 W=2.5e-05
M54 VSS 7 VDDO VSS n18pcesd L=2.5e-07 W=2.5e-05
M55 VDD 8 VSS VSS n18pcesd L=2.5e-07 W=2.5e-05
M56 VSS 8 VDD VSS n18pcesd L=2.5e-07 W=2.5e-05
M57 VDD 8 VSS VSS n18pcesd L=2.5e-07 W=2.5e-05
M58 VSS 8 VDD VSS n18pcesd L=2.5e-07 W=2.5e-05
M59 VDD 8 VSS VSS n18pcesd L=2.5e-07 W=2.5e-05
M60 VSS 8 VDD VSS n18pcesd L=2.5e-07 W=2.5e-05
M61 VDD 8 VSS VSS n18pcesd L=2.5e-07 W=2.5e-05
M62 VSS 8 VDD VSS n18pcesd L=2.5e-07 W=2.5e-05
M63 VDD 8 VSS VSS n18pcesd L=2.5e-07 W=2.5e-05
M64 VSS 8 VDD VSS n18pcesd L=2.5e-07 W=2.5e-05
M65 VDD 8 VSS VSS n18pcesd L=2.5e-07 W=2.5e-05
M66 VSS 8 VDD VSS n18pcesd L=2.5e-07 W=2.5e-05
M67 VDD 8 VSS VSS n18pcesd L=2.5e-07 W=2.5e-05
M68 VSS 8 VDD VSS n18pcesd L=2.5e-07 W=2.5e-05
M69 VDD 8 VSS VSS n18pcesd L=2.5e-07 W=2.5e-05
M70 VSS 8 VDD VSS n18pcesd L=2.5e-07 W=2.5e-05
M71 VDD 8 VSS VSS n18pcesd L=2.5e-07 W=2.5e-05
M72 VSS 8 VDD VSS n18pcesd L=2.5e-07 W=2.5e-05
M73 VDD 8 VSS VSS n18pcesd L=2.5e-07 W=2.5e-05
M74 VSS 8 VDD VSS n18pcesd L=2.5e-07 W=2.5e-05
D75 VSSO VSS dpnwcpl18 AREA=2.242e-11 PJ=3.25314e-05 nf=1
D76 VSSO VSS dpnwcpl18 AREA=2.242e-11 PJ=3.25314e-05 nf=1
D77 VSSO VSS dpnwcpl18 AREA=2.242e-11 PJ=3.25314e-05 nf=1
D78 VSSO VSS dpnwcpl18 AREA=2.242e-11 PJ=3.25314e-05 nf=1
D79 VSSO VSS dpnwcpl18 AREA=2.242e-11 PJ=3.25314e-05 nf=1
D80 VSSO VSS dpnwcpl18 AREA=2.242e-11 PJ=3.25314e-05 nf=1
D81 VSSO VSS dpnwcpl18 AREA=2.242e-11 PJ=3.25314e-05 nf=1
D82 VSS VSSO dpnwcpl18 AREA=2.242e-11 PJ=3.25314e-05 nf=1
D83 VSS VSSO dpnwcpl18 AREA=2.242e-11 PJ=3.25314e-05 nf=1
D84 VSS VSSO dpnwcpl18 AREA=2.242e-11 PJ=3.25314e-05 nf=1
D85 VSS VSSO dpnwcpl18 AREA=2.242e-11 PJ=3.25314e-05 nf=1
D86 VSS VSSO dpnwcpl18 AREA=2.242e-11 PJ=3.25314e-05 nf=1
D87 VSS VSSO dpnwcpl18 AREA=2.242e-11 PJ=3.25314e-05 nf=1
D88 VSS VSSO dpnwcpl18 AREA=2.242e-11 PJ=3.25314e-05 nf=1
.ENDS

.SUBCKT PV0I_50_18 VSS VDDO VSSO VDD
*.PININFO VSS:B VDDO:B VSSO:B VDD:B
M0 7 VDDO 7 VSS N5 L=4.55e-06 W=5.5e-06 rf_flag=0
M1 7 VDDO 7 VSS N5 L=4.55e-06 W=5.5e-06 rf_flag=0
M2 7 VDDO 7 VSS N5 L=4.55e-06 W=5.5e-06 rf_flag=0
M3 7 VDDO 7 VSS N5 L=4.55e-06 W=5.5e-06 rf_flag=0
M4 7 VDDO 7 VSS N5 L=4.55e-06 W=5.5e-06 rf_flag=0
M5 7 VDDO 7 VSS N5 L=4.55e-06 W=5.5e-06 rf_flag=0
M6 7 VDDO 7 VSS N5 L=4.55e-06 W=5.5e-06 rf_flag=0
M7 7 VDDO 7 VSS N5 L=4.55e-06 W=5.5e-06 rf_flag=0
M8 7 VDDO 7 VSS N5 L=4.55e-06 W=5.5e-06 rf_flag=0
M9 7 VDDO 7 VSS N5 L=4.55e-06 W=5.5e-06 rf_flag=0
M10 8 VDD 8 VSS N L=4.55e-06 W=5.5e-06 rf_flag=0
M11 8 VDD 8 VSS N L=4.55e-06 W=5.5e-06 rf_flag=0
M12 8 VDD 8 VSS N L=4.55e-06 W=5.5e-06 rf_flag=0
M13 8 VDD 8 VSS N L=4.55e-06 W=5.5e-06 rf_flag=0
M14 8 VDD 8 VSS N L=4.55e-06 W=5.5e-06 rf_flag=0
M15 8 VDD 8 VSS N L=4.55e-06 W=5.5e-06 rf_flag=0
M16 8 VDD 8 VSS N L=4.55e-06 W=5.5e-06 rf_flag=0
M17 8 VDD 8 VSS N L=4.55e-06 W=5.5e-06 rf_flag=0
M18 8 VDD 8 VSS N L=4.55e-06 W=5.5e-06 rf_flag=0
M19 8 VDD 8 VSS N L=4.55e-06 W=5.5e-06 rf_flag=0
R20 5 VSS 8325.14 L=4e-05 W=2e-06 postlayout=1 $SUB=VSS $[RE3]
R21 6 VSS 8325.14 L=4e-05 W=2e-06 postlayout=1 $SUB=VSS $[RE3]
R22 5 7 8325.14 L=4e-05 W=2e-06 postlayout=1 $SUB=VSS $[RE3]
R23 6 8 8325.14 L=4e-05 W=2e-06 postlayout=1 $SUB=VSS $[RE3]
D24 VSS VDDO dwn2psub AREA=8.1828e-10 PJ=0.00081428
D25 VSS VDD dwn2psub AREA=8.1828e-10 PJ=0.00081428
D26 VSS VDDO dwn2psub AREA=8.1828e-10 PJ=0.00081428
D27 VSS VDD dwn2psub AREA=8.1828e-10 PJ=0.00081428
D28 VSS VDDO dwn2psub AREA=8.1828e-10 PJ=0.00081428
D29 VSS VDD dwn2psub AREA=8.1828e-10 PJ=0.00081428
D30 VSS VDDO dwn2psub AREA=4.957e-10 PJ=0.0004917
D31 VSS VDDO dwn2psub AREA=4.957e-10 PJ=0.0004917
D32 VSSO VDDO dwn2psub AREA=4.957e-10 PJ=0.0004917
D33 VSS VSS dwn2psub AREA=6.3709e-10 PJ=0.00010544
D34 VSSO VSSO dwn2psub AREA=6.3709e-10 PJ=0.00010544
M35 VDD 8 VSS VSS n18pcesd L=2.5e-07 W=2.5e-05
M36 VSS 8 VDD VSS n18pcesd L=2.5e-07 W=2.5e-05
M37 VDD 8 VSS VSS n18pcesd L=2.5e-07 W=2.5e-05
M38 VSS 8 VDD VSS n18pcesd L=2.5e-07 W=2.5e-05
M39 VDD 8 VSS VSS n18pcesd L=2.5e-07 W=2.5e-05
M40 VSS 8 VDD VSS n18pcesd L=2.5e-07 W=2.5e-05
M41 VDD 8 VSS VSS n18pcesd L=2.5e-07 W=2.5e-05
M42 VSS 8 VDD VSS n18pcesd L=2.5e-07 W=2.5e-05
M43 VDD 8 VSS VSS n18pcesd L=2.5e-07 W=2.5e-05
M44 VSS 8 VDD VSS n18pcesd L=2.5e-07 W=2.5e-05
M45 VDD 8 VSS VSS n18pcesd L=2.5e-07 W=2.5e-05
M46 VSS 8 VDD VSS n18pcesd L=2.5e-07 W=2.5e-05
M47 VDD 8 VSS VSS n18pcesd L=2.5e-07 W=2.5e-05
M48 VSS 8 VDD VSS n18pcesd L=2.5e-07 W=2.5e-05
M49 VDD 8 VSS VSS n18pcesd L=2.5e-07 W=2.5e-05
M50 VSS 8 VDD VSS n18pcesd L=2.5e-07 W=2.5e-05
M51 VDD 8 VSS VSS n18pcesd L=2.5e-07 W=2.5e-05
M52 VSS 8 VDD VSS n18pcesd L=2.5e-07 W=2.5e-05
M53 VDD 8 VSS VSS n18pcesd L=2.5e-07 W=2.5e-05
M54 VSS 8 VDD VSS n18pcesd L=2.5e-07 W=2.5e-05
M55 VDDO 7 VSS VSS n5pcesd L=6e-07 W=2.5e-05
M56 VSS 7 VDDO VSS n5pcesd L=6e-07 W=2.5e-05
M57 VDDO 7 VSS VSS n5pcesd L=6e-07 W=2.5e-05
M58 VSS 7 VDDO VSS n5pcesd L=6e-07 W=2.5e-05
M59 VDDO 7 VSS VSS n5pcesd L=6e-07 W=2.5e-05
M60 VSS 7 VDDO VSS n5pcesd L=6e-07 W=2.5e-05
M61 VDDO 7 VSS VSS n5pcesd L=6e-07 W=2.5e-05
M62 VSS 7 VDDO VSS n5pcesd L=6e-07 W=2.5e-05
M63 VDDO 7 VSS VSS n5pcesd L=6e-07 W=2.5e-05
M64 VSS 7 VDDO VSS n5pcesd L=6e-07 W=2.5e-05
M65 VDDO 7 VSS VSS n5pcesd L=6e-07 W=2.5e-05
M66 VSS 7 VDDO VSS n5pcesd L=6e-07 W=2.5e-05
M67 VDDO 7 VSS VSS n5pcesd L=6e-07 W=2.5e-05
M68 VSS 7 VDDO VSS n5pcesd L=6e-07 W=2.5e-05
M69 VDDO 7 VSS VSS n5pcesd L=6e-07 W=2.5e-05
M70 VSS 7 VDDO VSS n5pcesd L=6e-07 W=2.5e-05
M71 VDDO 7 VSS VSS n5pcesd L=6e-07 W=2.5e-05
M72 VSS 7 VDDO VSS n5pcesd L=6e-07 W=2.5e-05
M73 VDDO 7 VSS VSS n5pcesd L=6e-07 W=2.5e-05
M74 VSS 7 VDDO VSS n5pcesd L=6e-07 W=2.5e-05
D75 VSSO VSS dpnwcpl5 AREA=2.242e-11 PJ=3.25314e-05 nf=1
D76 VSSO VSS dpnwcpl5 AREA=2.242e-11 PJ=3.25314e-05 nf=1
D77 VSSO VSS dpnwcpl5 AREA=2.242e-11 PJ=3.25314e-05 nf=1
D78 VSSO VSS dpnwcpl5 AREA=2.242e-11 PJ=3.25314e-05 nf=1
D79 VSSO VSS dpnwcpl5 AREA=2.242e-11 PJ=3.25314e-05 nf=1
D80 VSSO VSS dpnwcpl5 AREA=2.242e-11 PJ=3.25314e-05 nf=1
D81 VSSO VSS dpnwcpl5 AREA=2.242e-11 PJ=3.25314e-05 nf=1
D82 VSS VSSO dpnwcpl5 AREA=2.242e-11 PJ=3.25314e-05 nf=1
D83 VSS VSSO dpnwcpl5 AREA=2.242e-11 PJ=3.25314e-05 nf=1
D84 VSS VSSO dpnwcpl5 AREA=2.242e-11 PJ=3.25314e-05 nf=1
D85 VSS VSSO dpnwcpl5 AREA=2.242e-11 PJ=3.25314e-05 nf=1
D86 VSS VSSO dpnwcpl5 AREA=2.242e-11 PJ=3.25314e-05 nf=1
D87 VSS VSSO dpnwcpl5 AREA=2.242e-11 PJ=3.25314e-05 nf=1
D88 VSS VSSO dpnwcpl5 AREA=2.242e-11 PJ=3.25314e-05 nf=1
.ENDS

.SUBCKT PV0I_50_50 VSS VDDO VSSO VDD
*.PININFO VSS:B VDDO:B VSSO:B VDD:B
M0 7 VDDO 7 VSS N5 L=4.55e-06 W=5.5e-06 rf_flag=0
M1 7 VDDO 7 VSS N5 L=4.55e-06 W=5.5e-06 rf_flag=0
M2 7 VDDO 7 VSS N5 L=4.55e-06 W=5.5e-06 rf_flag=0
M3 7 VDDO 7 VSS N5 L=4.55e-06 W=5.5e-06 rf_flag=0
M4 7 VDDO 7 VSS N5 L=4.55e-06 W=5.5e-06 rf_flag=0
M5 7 VDDO 7 VSS N5 L=4.55e-06 W=5.5e-06 rf_flag=0
M6 7 VDDO 7 VSS N5 L=4.55e-06 W=5.5e-06 rf_flag=0
M7 7 VDDO 7 VSS N5 L=4.55e-06 W=5.5e-06 rf_flag=0
M8 7 VDDO 7 VSS N5 L=4.55e-06 W=5.5e-06 rf_flag=0
M9 7 VDDO 7 VSS N5 L=4.55e-06 W=5.5e-06 rf_flag=0
M10 8 VDD 8 VSS N5 L=4.55e-06 W=5.5e-06 rf_flag=0
M11 8 VDD 8 VSS N5 L=4.55e-06 W=5.5e-06 rf_flag=0
M12 8 VDD 8 VSS N5 L=4.55e-06 W=5.5e-06 rf_flag=0
M13 8 VDD 8 VSS N5 L=4.55e-06 W=5.5e-06 rf_flag=0
M14 8 VDD 8 VSS N5 L=4.55e-06 W=5.5e-06 rf_flag=0
M15 8 VDD 8 VSS N5 L=4.55e-06 W=5.5e-06 rf_flag=0
M16 8 VDD 8 VSS N5 L=4.55e-06 W=5.5e-06 rf_flag=0
M17 8 VDD 8 VSS N5 L=4.55e-06 W=5.5e-06 rf_flag=0
M18 8 VDD 8 VSS N5 L=4.55e-06 W=5.5e-06 rf_flag=0
M19 8 VDD 8 VSS N5 L=4.55e-06 W=5.5e-06 rf_flag=0
R20 5 VSS 8325.14 L=4e-05 W=2e-06 postlayout=1 $SUB=VSS $[RE3]
R21 6 VSS 8325.14 L=4e-05 W=2e-06 postlayout=1 $SUB=VSS $[RE3]
R22 5 7 8325.14 L=4e-05 W=2e-06 postlayout=1 $SUB=VSS $[RE3]
R23 6 8 8325.14 L=4e-05 W=2e-06 postlayout=1 $SUB=VSS $[RE3]
D24 VSS VDDO dwn2psub AREA=8.1828e-10 PJ=0.00081428
D25 VSS VDD dwn2psub AREA=8.1828e-10 PJ=0.00081428
D26 VSS VDDO dwn2psub AREA=8.1828e-10 PJ=0.00081428
D27 VSS VDD dwn2psub AREA=8.1828e-10 PJ=0.00081428
D28 VSS VDDO dwn2psub AREA=8.1828e-10 PJ=0.00081428
D29 VSS VDD dwn2psub AREA=8.1828e-10 PJ=0.00081428
D30 VSS VDDO dwn2psub AREA=4.957e-10 PJ=0.0004917
D31 VSS VDDO dwn2psub AREA=4.957e-10 PJ=0.0004917
D32 VSSO VDDO dwn2psub AREA=4.957e-10 PJ=0.0004917
D33 VSS VSS dwn2psub AREA=6.3709e-10 PJ=0.00010544
D34 VSSO VSSO dwn2psub AREA=6.3709e-10 PJ=0.00010544
M35 VDDO 7 VSS VSS n5pcesd L=6e-07 W=2.5e-05
M36 VSS 7 VDDO VSS n5pcesd L=6e-07 W=2.5e-05
M37 VDDO 7 VSS VSS n5pcesd L=6e-07 W=2.5e-05
M38 VSS 7 VDDO VSS n5pcesd L=6e-07 W=2.5e-05
M39 VDDO 7 VSS VSS n5pcesd L=6e-07 W=2.5e-05
M40 VSS 7 VDDO VSS n5pcesd L=6e-07 W=2.5e-05
M41 VDDO 7 VSS VSS n5pcesd L=6e-07 W=2.5e-05
M42 VSS 7 VDDO VSS n5pcesd L=6e-07 W=2.5e-05
M43 VDDO 7 VSS VSS n5pcesd L=6e-07 W=2.5e-05
M44 VSS 7 VDDO VSS n5pcesd L=6e-07 W=2.5e-05
M45 VDDO 7 VSS VSS n5pcesd L=6e-07 W=2.5e-05
M46 VSS 7 VDDO VSS n5pcesd L=6e-07 W=2.5e-05
M47 VDDO 7 VSS VSS n5pcesd L=6e-07 W=2.5e-05
M48 VSS 7 VDDO VSS n5pcesd L=6e-07 W=2.5e-05
M49 VDDO 7 VSS VSS n5pcesd L=6e-07 W=2.5e-05
M50 VSS 7 VDDO VSS n5pcesd L=6e-07 W=2.5e-05
M51 VDDO 7 VSS VSS n5pcesd L=6e-07 W=2.5e-05
M52 VSS 7 VDDO VSS n5pcesd L=6e-07 W=2.5e-05
M53 VDDO 7 VSS VSS n5pcesd L=6e-07 W=2.5e-05
M54 VSS 7 VDDO VSS n5pcesd L=6e-07 W=2.5e-05
M55 VDD 8 VSS VSS n5pcesd L=6e-07 W=2.5e-05
M56 VSS 8 VDD VSS n5pcesd L=6e-07 W=2.5e-05
M57 VDD 8 VSS VSS n5pcesd L=6e-07 W=2.5e-05
M58 VSS 8 VDD VSS n5pcesd L=6e-07 W=2.5e-05
M59 VDD 8 VSS VSS n5pcesd L=6e-07 W=2.5e-05
M60 VSS 8 VDD VSS n5pcesd L=6e-07 W=2.5e-05
M61 VDD 8 VSS VSS n5pcesd L=6e-07 W=2.5e-05
M62 VSS 8 VDD VSS n5pcesd L=6e-07 W=2.5e-05
M63 VDD 8 VSS VSS n5pcesd L=6e-07 W=2.5e-05
M64 VSS 8 VDD VSS n5pcesd L=6e-07 W=2.5e-05
M65 VDD 8 VSS VSS n5pcesd L=6e-07 W=2.5e-05
M66 VSS 8 VDD VSS n5pcesd L=6e-07 W=2.5e-05
M67 VDD 8 VSS VSS n5pcesd L=6e-07 W=2.5e-05
M68 VSS 8 VDD VSS n5pcesd L=6e-07 W=2.5e-05
M69 VDD 8 VSS VSS n5pcesd L=6e-07 W=2.5e-05
M70 VSS 8 VDD VSS n5pcesd L=6e-07 W=2.5e-05
M71 VDD 8 VSS VSS n5pcesd L=6e-07 W=2.5e-05
M72 VSS 8 VDD VSS n5pcesd L=6e-07 W=2.5e-05
M73 VDD 8 VSS VSS n5pcesd L=6e-07 W=2.5e-05
M74 VSS 8 VDD VSS n5pcesd L=6e-07 W=2.5e-05
D75 VSSO VSS dpnwcpl5 AREA=2.242e-11 PJ=3.25314e-05 nf=1
D76 VSSO VSS dpnwcpl5 AREA=2.242e-11 PJ=3.25314e-05 nf=1
D77 VSSO VSS dpnwcpl5 AREA=2.242e-11 PJ=3.25314e-05 nf=1
D78 VSSO VSS dpnwcpl5 AREA=2.242e-11 PJ=3.25314e-05 nf=1
D79 VSSO VSS dpnwcpl5 AREA=2.242e-11 PJ=3.25314e-05 nf=1
D80 VSSO VSS dpnwcpl5 AREA=2.242e-11 PJ=3.25314e-05 nf=1
D81 VSSO VSS dpnwcpl5 AREA=2.242e-11 PJ=3.25314e-05 nf=1
D82 VSS VSSO dpnwcpl5 AREA=2.242e-11 PJ=3.25314e-05 nf=1
D83 VSS VSSO dpnwcpl5 AREA=2.242e-11 PJ=3.25314e-05 nf=1
D84 VSS VSSO dpnwcpl5 AREA=2.242e-11 PJ=3.25314e-05 nf=1
D85 VSS VSSO dpnwcpl5 AREA=2.242e-11 PJ=3.25314e-05 nf=1
D86 VSS VSSO dpnwcpl5 AREA=2.242e-11 PJ=3.25314e-05 nf=1
D87 VSS VSSO dpnwcpl5 AREA=2.242e-11 PJ=3.25314e-05 nf=1
D88 VSS VSSO dpnwcpl5 AREA=2.242e-11 PJ=3.25314e-05 nf=1
.ENDS

.SUBCKT PVDA_18_NA VDDO VSSO VSS VDD
*.PININFO VDDO:B VSSO:B VSS:B VDD:B
M0 6 VDDO 6 VSS N L=4.55e-06 W=5.5e-06 rf_flag=0
M1 6 VDDO 6 VSS N L=4.55e-06 W=5.5e-06 rf_flag=0
M2 6 VDDO 6 VSS N L=4.55e-06 W=5.5e-06 rf_flag=0
M3 6 VDDO 6 VSS N L=4.55e-06 W=5.5e-06 rf_flag=0
M4 6 VDDO 6 VSS N L=4.55e-06 W=5.5e-06 rf_flag=0
M5 6 VDDO 6 VSS N L=4.55e-06 W=5.5e-06 rf_flag=0
M6 6 VDDO 6 VSS N L=4.55e-06 W=5.5e-06 rf_flag=0
M7 6 VDDO 6 VSS N L=4.55e-06 W=5.5e-06 rf_flag=0
M8 6 VDDO 6 VSS N L=4.55e-06 W=5.5e-06 rf_flag=0
M9 6 VDDO 6 VSS N L=4.55e-06 W=5.5e-06 rf_flag=0
M10 7 VDDO 7 VSSO N L=4.55e-06 W=5.5e-06 rf_flag=0
M11 7 VDDO 7 VSSO N L=4.55e-06 W=5.5e-06 rf_flag=0
M12 7 VDDO 7 VSSO N L=4.55e-06 W=5.5e-06 rf_flag=0
M13 7 VDDO 7 VSSO N L=4.55e-06 W=5.5e-06 rf_flag=0
M14 7 VDDO 7 VSSO N L=4.55e-06 W=5.5e-06 rf_flag=0
M15 7 VDDO 7 VSSO N L=4.55e-06 W=5.5e-06 rf_flag=0
M16 7 VDDO 7 VSSO N L=4.55e-06 W=5.5e-06 rf_flag=0
M17 7 VDDO 7 VSSO N L=4.55e-06 W=5.5e-06 rf_flag=0
M18 7 VDDO 7 VSSO N L=4.55e-06 W=5.5e-06 rf_flag=0
M19 7 VDDO 7 VSSO N L=4.55e-06 W=5.5e-06 rf_flag=0
R20 VSS 5 8325.14 L=4e-05 W=2e-06 postlayout=1 $SUB=VSS $[RE3]
R21 6 5 8325.14 L=4e-05 W=2e-06 postlayout=1 $SUB=VSS $[RE3]
R22 7 8 8325.14 L=4e-05 W=2e-06 postlayout=1 $SUB=VSSO $[RE3]
R23 VSSO 8 8325.14 L=4e-05 W=2e-06 postlayout=1 $SUB=VSSO $[RE3]
D24 VSS VDDO dwn2psub AREA=1.42129e-09 PJ=0.00140929
D25 VSS VDDO dwn2psub AREA=1.42129e-09 PJ=0.00140929
D26 VSS VDDO dwn2psub AREA=1.42129e-09 PJ=0.00140929
D27 VSS VDDO dwn2psub AREA=4.8412e-10 PJ=0.00048012
D28 VSSO VDDO dwn2psub AREA=4.8412e-10 PJ=0.00048012
D29 VSSO VSSO dwn2psub AREA=6.3409e-10 PJ=0.00011544
D30 VSSO VDDO dwn2psub AREA=1.42129e-09 PJ=0.00140929
D31 VSSO VDDO dwn2psub AREA=4.8412e-10 PJ=0.00048012
D32 VSSO VSS dwn2psub AREA=6.3409e-10 PJ=0.00011544
D33 VSSO VDDO dwn2psub AREA=1.42129e-09 PJ=0.00140929
M34 VDDO 6 VSS VSS n18pcesd L=2.5e-07 W=2.5e-05
M35 VSS 6 VDDO VSS n18pcesd L=2.5e-07 W=2.5e-05
M36 VDDO 6 VSS VSS n18pcesd L=2.5e-07 W=2.5e-05
M37 VSS 6 VDDO VSS n18pcesd L=2.5e-07 W=2.5e-05
M38 VDDO 6 VSS VSS n18pcesd L=2.5e-07 W=2.5e-05
M39 VSS 6 VDDO VSS n18pcesd L=2.5e-07 W=2.5e-05
M40 VDDO 6 VSS VSS n18pcesd L=2.5e-07 W=2.5e-05
M41 VSS 6 VDDO VSS n18pcesd L=2.5e-07 W=2.5e-05
M42 VDDO 6 VSS VSS n18pcesd L=2.5e-07 W=2.5e-05
M43 VSS 6 VDDO VSS n18pcesd L=2.5e-07 W=2.5e-05
M44 VDDO 6 VSS VSS n18pcesd L=2.5e-07 W=2.5e-05
M45 VSS 6 VDDO VSS n18pcesd L=2.5e-07 W=2.5e-05
M46 VDDO 6 VSS VSS n18pcesd L=2.5e-07 W=2.5e-05
M47 VSS 6 VDDO VSS n18pcesd L=2.5e-07 W=2.5e-05
M48 VDDO 6 VSS VSS n18pcesd L=2.5e-07 W=2.5e-05
M49 VSS 6 VDDO VSS n18pcesd L=2.5e-07 W=2.5e-05
M50 VDDO 6 VSS VSS n18pcesd L=2.5e-07 W=2.5e-05
M51 VSS 6 VDDO VSS n18pcesd L=2.5e-07 W=2.5e-05
M52 VDDO 6 VSS VSS n18pcesd L=2.5e-07 W=2.5e-05
M53 VSS 6 VDDO VSS n18pcesd L=2.5e-07 W=2.5e-05
M54 VDDO 7 VSSO VSSO n18pcesd L=2.5e-07 W=2.5e-05
M55 VSSO 7 VDDO VSSO n18pcesd L=2.5e-07 W=2.5e-05
M56 VDDO 7 VSSO VSSO n18pcesd L=2.5e-07 W=2.5e-05
M57 VSSO 7 VDDO VSSO n18pcesd L=2.5e-07 W=2.5e-05
M58 VDDO 7 VSSO VSSO n18pcesd L=2.5e-07 W=2.5e-05
M59 VSSO 7 VDDO VSSO n18pcesd L=2.5e-07 W=2.5e-05
M60 VDDO 7 VSSO VSSO n18pcesd L=2.5e-07 W=2.5e-05
M61 VSSO 7 VDDO VSSO n18pcesd L=2.5e-07 W=2.5e-05
M62 VDDO 7 VSSO VSSO n18pcesd L=2.5e-07 W=2.5e-05
M63 VSSO 7 VDDO VSSO n18pcesd L=2.5e-07 W=2.5e-05
M64 VDDO 7 VSSO VSSO n18pcesd L=2.5e-07 W=2.5e-05
M65 VSSO 7 VDDO VSSO n18pcesd L=2.5e-07 W=2.5e-05
M66 VDDO 7 VSSO VSSO n18pcesd L=2.5e-07 W=2.5e-05
M67 VSSO 7 VDDO VSSO n18pcesd L=2.5e-07 W=2.5e-05
M68 VDDO 7 VSSO VSSO n18pcesd L=2.5e-07 W=2.5e-05
M69 VSSO 7 VDDO VSSO n18pcesd L=2.5e-07 W=2.5e-05
M70 VDDO 7 VSSO VSSO n18pcesd L=2.5e-07 W=2.5e-05
M71 VSSO 7 VDDO VSSO n18pcesd L=2.5e-07 W=2.5e-05
M72 VDDO 7 VSSO VSSO n18pcesd L=2.5e-07 W=2.5e-05
M73 VSSO 7 VDDO VSSO n18pcesd L=2.5e-07 W=2.5e-05
D74 VSS VSSO dpnwcpl18 AREA=1.642e-11 PJ=2.45314e-05 nf=1
D75 VSS VSSO dpnwcpl18 AREA=1.642e-11 PJ=2.45314e-05 nf=1
D76 VSS VSSO dpnwcpl18 AREA=1.642e-11 PJ=2.45314e-05 nf=1
D77 VSS VSSO dpnwcpl18 AREA=1.642e-11 PJ=2.45314e-05 nf=1
D78 VSS VSSO dpnwcpl18 AREA=1.642e-11 PJ=2.45314e-05 nf=1
D79 VSS VSSO dpnwcpl18 AREA=1.642e-11 PJ=2.45314e-05 nf=1
D80 VSS VSSO dpnwcpl18 AREA=1.642e-11 PJ=2.45314e-05 nf=1
D81 VSS VSSO dpnwcpl18 AREA=1.642e-11 PJ=2.45314e-05 nf=1
D82 VSS VSSO dpnwcpl18 AREA=1.642e-11 PJ=2.45314e-05 nf=1
D83 VSSO VSS dpnwcpl18 AREA=1.642e-11 PJ=2.45314e-05 nf=1
D84 VSSO VSS dpnwcpl18 AREA=1.642e-11 PJ=2.45314e-05 nf=1
D85 VSSO VSS dpnwcpl18 AREA=1.642e-11 PJ=2.45314e-05 nf=1
D86 VSSO VSS dpnwcpl18 AREA=1.642e-11 PJ=2.45314e-05 nf=1
D87 VSSO VSS dpnwcpl18 AREA=1.642e-11 PJ=2.45314e-05 nf=1
D88 VSSO VSS dpnwcpl18 AREA=1.642e-11 PJ=2.45314e-05 nf=1
D89 VSSO VSS dpnwcpl18 AREA=1.642e-11 PJ=2.45314e-05 nf=1
D90 VSSO VSS dpnwcpl18 AREA=1.642e-11 PJ=2.45314e-05 nf=1
D91 VSSO VSS dpnwcpl18 AREA=1.642e-11 PJ=2.45314e-05 nf=1
.ENDS

.SUBCKT PVDA_50_NA VDDO VSSO VSS VDD
*.PININFO VDDO:B VSSO:B VSS:B VDD:B
M0 6 VDDO 6 VSS N5 L=4.55e-06 W=5.5e-06 rf_flag=0
M1 6 VDDO 6 VSS N5 L=4.55e-06 W=5.5e-06 rf_flag=0
M2 6 VDDO 6 VSS N5 L=4.55e-06 W=5.5e-06 rf_flag=0
M3 6 VDDO 6 VSS N5 L=4.55e-06 W=5.5e-06 rf_flag=0
M4 6 VDDO 6 VSS N5 L=4.55e-06 W=5.5e-06 rf_flag=0
M5 6 VDDO 6 VSS N5 L=4.55e-06 W=5.5e-06 rf_flag=0
M6 6 VDDO 6 VSS N5 L=4.55e-06 W=5.5e-06 rf_flag=0
M7 6 VDDO 6 VSS N5 L=4.55e-06 W=5.5e-06 rf_flag=0
M8 6 VDDO 6 VSS N5 L=4.55e-06 W=5.5e-06 rf_flag=0
M9 6 VDDO 6 VSS N5 L=4.55e-06 W=5.5e-06 rf_flag=0
M10 7 VDDO 7 VSSO N5 L=4.55e-06 W=5.5e-06 rf_flag=0
M11 7 VDDO 7 VSSO N5 L=4.55e-06 W=5.5e-06 rf_flag=0
M12 7 VDDO 7 VSSO N5 L=4.55e-06 W=5.5e-06 rf_flag=0
M13 7 VDDO 7 VSSO N5 L=4.55e-06 W=5.5e-06 rf_flag=0
M14 7 VDDO 7 VSSO N5 L=4.55e-06 W=5.5e-06 rf_flag=0
M15 7 VDDO 7 VSSO N5 L=4.55e-06 W=5.5e-06 rf_flag=0
M16 7 VDDO 7 VSSO N5 L=4.55e-06 W=5.5e-06 rf_flag=0
M17 7 VDDO 7 VSSO N5 L=4.55e-06 W=5.5e-06 rf_flag=0
M18 7 VDDO 7 VSSO N5 L=4.55e-06 W=5.5e-06 rf_flag=0
M19 7 VDDO 7 VSSO N5 L=4.55e-06 W=5.5e-06 rf_flag=0
R20 VSS 5 8325.14 L=4e-05 W=2e-06 postlayout=1 $SUB=VSS $[RE3]
R21 6 5 8325.14 L=4e-05 W=2e-06 postlayout=1 $SUB=VSS $[RE3]
R22 7 8 8325.14 L=4e-05 W=2e-06 postlayout=1 $SUB=VSSO $[RE3]
R23 VSSO 8 8325.14 L=4e-05 W=2e-06 postlayout=1 $SUB=VSSO $[RE3]
D24 VSS VDDO dwn2psub AREA=1.42129e-09 PJ=0.00140929
D25 VSS VDDO dwn2psub AREA=1.42129e-09 PJ=0.00140929
D26 VSS VDDO dwn2psub AREA=1.42129e-09 PJ=0.00140929
D27 VSS VDDO dwn2psub AREA=4.8412e-10 PJ=0.00048012
D28 VSSO VDDO dwn2psub AREA=4.8412e-10 PJ=0.00048012
D29 VSSO VSSO dwn2psub AREA=6.3409e-10 PJ=0.00011544
D30 VSSO VDDO dwn2psub AREA=1.42129e-09 PJ=0.00140929
D31 VSSO VDDO dwn2psub AREA=4.8412e-10 PJ=0.00048012
D32 VSSO VSS dwn2psub AREA=6.3409e-10 PJ=0.00011544
D33 VSSO VDDO dwn2psub AREA=1.42129e-09 PJ=0.00140929
M34 VDDO 6 VSS VSS n5pcesd L=6e-07 W=2.5e-05
M35 VSS 6 VDDO VSS n5pcesd L=6e-07 W=2.5e-05
M36 VDDO 6 VSS VSS n5pcesd L=6e-07 W=2.5e-05
M37 VSS 6 VDDO VSS n5pcesd L=6e-07 W=2.5e-05
M38 VDDO 6 VSS VSS n5pcesd L=6e-07 W=2.5e-05
M39 VSS 6 VDDO VSS n5pcesd L=6e-07 W=2.5e-05
M40 VDDO 6 VSS VSS n5pcesd L=6e-07 W=2.5e-05
M41 VSS 6 VDDO VSS n5pcesd L=6e-07 W=2.5e-05
M42 VDDO 6 VSS VSS n5pcesd L=6e-07 W=2.5e-05
M43 VSS 6 VDDO VSS n5pcesd L=6e-07 W=2.5e-05
M44 VDDO 6 VSS VSS n5pcesd L=6e-07 W=2.5e-05
M45 VSS 6 VDDO VSS n5pcesd L=6e-07 W=2.5e-05
M46 VDDO 6 VSS VSS n5pcesd L=6e-07 W=2.5e-05
M47 VSS 6 VDDO VSS n5pcesd L=6e-07 W=2.5e-05
M48 VDDO 6 VSS VSS n5pcesd L=6e-07 W=2.5e-05
M49 VSS 6 VDDO VSS n5pcesd L=6e-07 W=2.5e-05
M50 VDDO 6 VSS VSS n5pcesd L=6e-07 W=2.5e-05
M51 VSS 6 VDDO VSS n5pcesd L=6e-07 W=2.5e-05
M52 VDDO 6 VSS VSS n5pcesd L=6e-07 W=2.5e-05
M53 VSS 6 VDDO VSS n5pcesd L=6e-07 W=2.5e-05
M54 VDDO 7 VSSO VSSO n5pcesd L=6e-07 W=2.5e-05
M55 VSSO 7 VDDO VSSO n5pcesd L=6e-07 W=2.5e-05
M56 VDDO 7 VSSO VSSO n5pcesd L=6e-07 W=2.5e-05
M57 VSSO 7 VDDO VSSO n5pcesd L=6e-07 W=2.5e-05
M58 VDDO 7 VSSO VSSO n5pcesd L=6e-07 W=2.5e-05
M59 VSSO 7 VDDO VSSO n5pcesd L=6e-07 W=2.5e-05
M60 VDDO 7 VSSO VSSO n5pcesd L=6e-07 W=2.5e-05
M61 VSSO 7 VDDO VSSO n5pcesd L=6e-07 W=2.5e-05
M62 VDDO 7 VSSO VSSO n5pcesd L=6e-07 W=2.5e-05
M63 VSSO 7 VDDO VSSO n5pcesd L=6e-07 W=2.5e-05
M64 VDDO 7 VSSO VSSO n5pcesd L=6e-07 W=2.5e-05
M65 VSSO 7 VDDO VSSO n5pcesd L=6e-07 W=2.5e-05
M66 VDDO 7 VSSO VSSO n5pcesd L=6e-07 W=2.5e-05
M67 VSSO 7 VDDO VSSO n5pcesd L=6e-07 W=2.5e-05
M68 VDDO 7 VSSO VSSO n5pcesd L=6e-07 W=2.5e-05
M69 VSSO 7 VDDO VSSO n5pcesd L=6e-07 W=2.5e-05
M70 VDDO 7 VSSO VSSO n5pcesd L=6e-07 W=2.5e-05
M71 VSSO 7 VDDO VSSO n5pcesd L=6e-07 W=2.5e-05
M72 VDDO 7 VSSO VSSO n5pcesd L=6e-07 W=2.5e-05
M73 VSSO 7 VDDO VSSO n5pcesd L=6e-07 W=2.5e-05
D74 VSS VSSO dpnwcpl5 AREA=1.642e-11 PJ=2.45314e-05 nf=1
D75 VSS VSSO dpnwcpl5 AREA=1.642e-11 PJ=2.45314e-05 nf=1
D76 VSS VSSO dpnwcpl5 AREA=1.642e-11 PJ=2.45314e-05 nf=1
D77 VSS VSSO dpnwcpl5 AREA=1.642e-11 PJ=2.45314e-05 nf=1
D78 VSS VSSO dpnwcpl5 AREA=1.642e-11 PJ=2.45314e-05 nf=1
D79 VSS VSSO dpnwcpl5 AREA=1.642e-11 PJ=2.45314e-05 nf=1
D80 VSS VSSO dpnwcpl5 AREA=1.642e-11 PJ=2.45314e-05 nf=1
D81 VSS VSSO dpnwcpl5 AREA=1.642e-11 PJ=2.45314e-05 nf=1
D82 VSS VSSO dpnwcpl5 AREA=1.642e-11 PJ=2.45314e-05 nf=1
D83 VSSO VSS dpnwcpl5 AREA=1.642e-11 PJ=2.45314e-05 nf=1
D84 VSSO VSS dpnwcpl5 AREA=1.642e-11 PJ=2.45314e-05 nf=1
D85 VSSO VSS dpnwcpl5 AREA=1.642e-11 PJ=2.45314e-05 nf=1
D86 VSSO VSS dpnwcpl5 AREA=1.642e-11 PJ=2.45314e-05 nf=1
D87 VSSO VSS dpnwcpl5 AREA=1.642e-11 PJ=2.45314e-05 nf=1
D88 VSSO VSS dpnwcpl5 AREA=1.642e-11 PJ=2.45314e-05 nf=1
D89 VSSO VSS dpnwcpl5 AREA=1.642e-11 PJ=2.45314e-05 nf=1
D90 VSSO VSS dpnwcpl5 AREA=1.642e-11 PJ=2.45314e-05 nf=1
D91 VSSO VSS dpnwcpl5 AREA=1.642e-11 PJ=2.45314e-05 nf=1
.ENDS

.SUBCKT PVDC_NA_NA_18 VDDC VDDO VSSO VSS VDD VSSC
*.PININFO VDDC:B VDDO:B VSSO:B VSS:B VDD:B VSSC:B
M0 8 VDDC 8 VSSO N L=4.55e-06 W=5.5e-06 rf_flag=0
M1 8 VDDC 8 VSSO N L=4.55e-06 W=5.5e-06 rf_flag=0
M2 8 VDDC 8 VSSO N L=4.55e-06 W=5.5e-06 rf_flag=0
M3 8 VDDC 8 VSSO N L=4.55e-06 W=5.5e-06 rf_flag=0
M4 8 VDDC 8 VSSO N L=4.55e-06 W=5.5e-06 rf_flag=0
M5 8 VDDC 8 VSSO N L=4.55e-06 W=5.5e-06 rf_flag=0
M6 8 VDDC 8 VSSO N L=4.55e-06 W=5.5e-06 rf_flag=0
M7 8 VDDC 8 VSSO N L=4.55e-06 W=5.5e-06 rf_flag=0
M8 8 VDDC 8 VSSO N L=4.55e-06 W=5.5e-06 rf_flag=0
M9 8 VDDC 8 VSSO N L=4.55e-06 W=5.5e-06 rf_flag=0
M10 9 VDDC 9 VSS N L=4.55e-06 W=5.5e-06 rf_flag=0
M11 9 VDDC 9 VSS N L=4.55e-06 W=5.5e-06 rf_flag=0
M12 9 VDDC 9 VSS N L=4.55e-06 W=5.5e-06 rf_flag=0
M13 9 VDDC 9 VSS N L=4.55e-06 W=5.5e-06 rf_flag=0
M14 9 VDDC 9 VSS N L=4.55e-06 W=5.5e-06 rf_flag=0
M15 9 VDDC 9 VSS N L=4.55e-06 W=5.5e-06 rf_flag=0
M16 9 VDDC 9 VSS N L=4.55e-06 W=5.5e-06 rf_flag=0
M17 9 VDDC 9 VSS N L=4.55e-06 W=5.5e-06 rf_flag=0
M18 9 VDDC 9 VSS N L=4.55e-06 W=5.5e-06 rf_flag=0
M19 9 VDDC 9 VSS N L=4.55e-06 W=5.5e-06 rf_flag=0
M20 10 VDDC 10 VSSC N L=4.55e-06 W=5.5e-06 rf_flag=0
M21 10 VDDC 10 VSSC N L=4.55e-06 W=5.5e-06 rf_flag=0
M22 10 VDDC 10 VSSC N L=4.55e-06 W=5.5e-06 rf_flag=0
M23 10 VDDC 10 VSSC N L=4.55e-06 W=5.5e-06 rf_flag=0
M24 10 VDDC 10 VSSC N L=4.55e-06 W=5.5e-06 rf_flag=0
M25 10 VDDC 10 VSSC N L=4.55e-06 W=5.5e-06 rf_flag=0
M26 10 VDDC 10 VSSC N L=4.55e-06 W=5.5e-06 rf_flag=0
M27 10 VDDC 10 VSSC N L=4.55e-06 W=5.5e-06 rf_flag=0
M28 10 VDDC 10 VSSC N L=4.55e-06 W=5.5e-06 rf_flag=0
M29 10 VDDC 10 VSSC N L=4.55e-06 W=5.5e-06 rf_flag=0
R30 VSSO 6 8325.14 L=4e-05 W=2e-06 postlayout=1 $SUB=VSSO $[RE3]
R31 7 VSS 8325.14 L=4e-05 W=2e-06 postlayout=1 $SUB=VSS $[RE3]
R32 8 6 8325.14 L=4e-05 W=2e-06 postlayout=1 $SUB=VSSO $[RE3]
R33 7 9 8325.14 L=4e-05 W=2e-06 postlayout=1 $SUB=VSS $[RE3]
R34 10 11 8325.14 L=4e-05 W=2e-06 postlayout=1 $SUB=VSSC $[RE3]
R35 VSSC 11 8325.14 L=4e-05 W=2e-06 postlayout=1 $SUB=VSSC $[RE3]
D36 VSSO VDDC dwn2psub AREA=3.82719e-09 PJ=0.00269537
D37 VSS VDDC dwn2psub AREA=3.82719e-09 PJ=0.00269537
D38 VSSO VDDC dwn2psub AREA=3.82719e-09 PJ=0.00269537
D39 VSS VDDC dwn2psub AREA=3.82719e-09 PJ=0.00269537
D40 VSSC VDDC dwn2psub AREA=3.82719e-09 PJ=0.00269537
D41 VSSO VDDC dwn2psub AREA=3.82719e-09 PJ=0.00269537
D42 VSS VDDC dwn2psub AREA=3.82719e-09 PJ=0.00269537
D43 VSSO VSSC dwn2psub AREA=6.3409e-10 PJ=0.00011544
D44 VSS VSSC dwn2psub AREA=6.3409e-10 PJ=0.00011544
D45 VSSO VDDC dwn2psub AREA=3.82719e-09 PJ=0.00269537
D46 VSS VDDC dwn2psub AREA=3.82719e-09 PJ=0.00269537
D47 VSSO VSSO dwn2psub AREA=6.3409e-10 PJ=0.00011544
D48 VSS VSS dwn2psub AREA=6.3409e-10 PJ=0.00011544
D49 VSSC VDDC dwn2psub AREA=3.82719e-09 PJ=0.00269537
D50 VSS VDDC dwn2psub AREA=3.82719e-09 PJ=0.00269537
M51 VDDC 8 VSSO VSSO n18pcesd L=2.5e-07 W=2.5e-05
M52 VSSO 8 VDDC VSSO n18pcesd L=2.5e-07 W=2.5e-05
M53 VDDC 8 VSSO VSSO n18pcesd L=2.5e-07 W=2.5e-05
M54 VSSO 8 VDDC VSSO n18pcesd L=2.5e-07 W=2.5e-05
M55 VDDC 8 VSSO VSSO n18pcesd L=2.5e-07 W=2.5e-05
M56 VSSO 8 VDDC VSSO n18pcesd L=2.5e-07 W=2.5e-05
M57 VDDC 8 VSSO VSSO n18pcesd L=2.5e-07 W=2.5e-05
M58 VSSO 8 VDDC VSSO n18pcesd L=2.5e-07 W=2.5e-05
M59 VDDC 8 VSSO VSSO n18pcesd L=2.5e-07 W=2.5e-05
M60 VSSO 8 VDDC VSSO n18pcesd L=2.5e-07 W=2.5e-05
M61 VDDC 8 VSSO VSSO n18pcesd L=2.5e-07 W=2.5e-05
M62 VSSO 8 VDDC VSSO n18pcesd L=2.5e-07 W=2.5e-05
M63 VDDC 8 VSSO VSSO n18pcesd L=2.5e-07 W=2.5e-05
M64 VSSO 8 VDDC VSSO n18pcesd L=2.5e-07 W=2.5e-05
M65 VDDC 8 VSSO VSSO n18pcesd L=2.5e-07 W=2.5e-05
M66 VSSO 8 VDDC VSSO n18pcesd L=2.5e-07 W=2.5e-05
M67 VDDC 8 VSSO VSSO n18pcesd L=2.5e-07 W=2.5e-05
M68 VSSO 8 VDDC VSSO n18pcesd L=2.5e-07 W=2.5e-05
M69 VDDC 8 VSSO VSSO n18pcesd L=2.5e-07 W=2.5e-05
M70 VSSO 8 VDDC VSSO n18pcesd L=2.5e-07 W=2.5e-05
M71 VDDC 9 VSS VSS n18pcesd L=2.5e-07 W=2.5e-05
M72 VSS 9 VDDC VSS n18pcesd L=2.5e-07 W=2.5e-05
M73 VDDC 9 VSS VSS n18pcesd L=2.5e-07 W=2.5e-05
M74 VSS 9 VDDC VSS n18pcesd L=2.5e-07 W=2.5e-05
M75 VDDC 9 VSS VSS n18pcesd L=2.5e-07 W=2.5e-05
M76 VSS 9 VDDC VSS n18pcesd L=2.5e-07 W=2.5e-05
M77 VDDC 9 VSS VSS n18pcesd L=2.5e-07 W=2.5e-05
M78 VSS 9 VDDC VSS n18pcesd L=2.5e-07 W=2.5e-05
M79 VDDC 9 VSS VSS n18pcesd L=2.5e-07 W=2.5e-05
M80 VSS 9 VDDC VSS n18pcesd L=2.5e-07 W=2.5e-05
M81 VDDC 9 VSS VSS n18pcesd L=2.5e-07 W=2.5e-05
M82 VSS 9 VDDC VSS n18pcesd L=2.5e-07 W=2.5e-05
M83 VDDC 9 VSS VSS n18pcesd L=2.5e-07 W=2.5e-05
M84 VSS 9 VDDC VSS n18pcesd L=2.5e-07 W=2.5e-05
M85 VDDC 9 VSS VSS n18pcesd L=2.5e-07 W=2.5e-05
M86 VSS 9 VDDC VSS n18pcesd L=2.5e-07 W=2.5e-05
M87 VDDC 9 VSS VSS n18pcesd L=2.5e-07 W=2.5e-05
M88 VSS 9 VDDC VSS n18pcesd L=2.5e-07 W=2.5e-05
M89 VDDC 9 VSS VSS n18pcesd L=2.5e-07 W=2.5e-05
M90 VSS 9 VDDC VSS n18pcesd L=2.5e-07 W=2.5e-05
M91 VDDC 10 VSSC VSSC n18pcesd L=2.5e-07 W=2.5e-05
M92 VSSC 10 VDDC VSSC n18pcesd L=2.5e-07 W=2.5e-05
M93 VDDC 10 VSSC VSSC n18pcesd L=2.5e-07 W=2.5e-05
M94 VSSC 10 VDDC VSSC n18pcesd L=2.5e-07 W=2.5e-05
M95 VDDC 10 VSSC VSSC n18pcesd L=2.5e-07 W=2.5e-05
M96 VSSC 10 VDDC VSSC n18pcesd L=2.5e-07 W=2.5e-05
M97 VDDC 10 VSSC VSSC n18pcesd L=2.5e-07 W=2.5e-05
M98 VSSC 10 VDDC VSSC n18pcesd L=2.5e-07 W=2.5e-05
M99 VDDC 10 VSSC VSSC n18pcesd L=2.5e-07 W=2.5e-05
M100 VSSC 10 VDDC VSSC n18pcesd L=2.5e-07 W=2.5e-05
M101 VDDC 10 VSSC VSSC n18pcesd L=2.5e-07 W=2.5e-05
M102 VSSC 10 VDDC VSSC n18pcesd L=2.5e-07 W=2.5e-05
M103 VDDC 10 VSSC VSSC n18pcesd L=2.5e-07 W=2.5e-05
M104 VSSC 10 VDDC VSSC n18pcesd L=2.5e-07 W=2.5e-05
M105 VDDC 10 VSSC VSSC n18pcesd L=2.5e-07 W=2.5e-05
M106 VSSC 10 VDDC VSSC n18pcesd L=2.5e-07 W=2.5e-05
M107 VDDC 10 VSSC VSSC n18pcesd L=2.5e-07 W=2.5e-05
M108 VSSC 10 VDDC VSSC n18pcesd L=2.5e-07 W=2.5e-05
M109 VDDC 10 VSSC VSSC n18pcesd L=2.5e-07 W=2.5e-05
M110 VSSC 10 VDDC VSSC n18pcesd L=2.5e-07 W=2.5e-05
D111 VSSO VSSC dpnwcpl18 AREA=1.642e-11 PJ=2.45314e-05 nf=1
D112 VSSO VSSC dpnwcpl18 AREA=1.642e-11 PJ=2.45314e-05 nf=1
D113 VSSO VSSC dpnwcpl18 AREA=1.642e-11 PJ=2.45314e-05 nf=1
D114 VSSO VSSC dpnwcpl18 AREA=1.642e-11 PJ=2.45314e-05 nf=1
D115 VSSO VSSC dpnwcpl18 AREA=1.642e-11 PJ=2.45314e-05 nf=1
D116 VSSO VSSC dpnwcpl18 AREA=1.642e-11 PJ=2.45314e-05 nf=1
D117 VSSO VSSC dpnwcpl18 AREA=1.642e-11 PJ=2.45314e-05 nf=1
D118 VSSO VSSC dpnwcpl18 AREA=1.642e-11 PJ=2.45314e-05 nf=1
D119 VSSO VSSC dpnwcpl18 AREA=1.642e-11 PJ=2.45314e-05 nf=1
D120 VSS VSSC dpnwcpl18 AREA=1.642e-11 PJ=2.45314e-05 nf=1
D121 VSS VSSC dpnwcpl18 AREA=1.642e-11 PJ=2.45314e-05 nf=1
D122 VSS VSSC dpnwcpl18 AREA=1.642e-11 PJ=2.45314e-05 nf=1
D123 VSS VSSC dpnwcpl18 AREA=1.642e-11 PJ=2.45314e-05 nf=1
D124 VSS VSSC dpnwcpl18 AREA=1.642e-11 PJ=2.45314e-05 nf=1
D125 VSS VSSC dpnwcpl18 AREA=1.642e-11 PJ=2.45314e-05 nf=1
D126 VSS VSSC dpnwcpl18 AREA=1.642e-11 PJ=2.45314e-05 nf=1
D127 VSS VSSC dpnwcpl18 AREA=1.642e-11 PJ=2.45314e-05 nf=1
D128 VSS VSSC dpnwcpl18 AREA=1.642e-11 PJ=2.45314e-05 nf=1
D129 VSSC VSSO dpnwcpl18 AREA=1.642e-11 PJ=2.45314e-05 nf=1
D130 VSSC VSSO dpnwcpl18 AREA=1.642e-11 PJ=2.45314e-05 nf=1
D131 VSSC VSSO dpnwcpl18 AREA=1.642e-11 PJ=2.45314e-05 nf=1
D132 VSSC VSSO dpnwcpl18 AREA=1.642e-11 PJ=2.45314e-05 nf=1
D133 VSSC VSSO dpnwcpl18 AREA=1.642e-11 PJ=2.45314e-05 nf=1
D134 VSSC VSSO dpnwcpl18 AREA=1.642e-11 PJ=2.45314e-05 nf=1
D135 VSSC VSSO dpnwcpl18 AREA=1.642e-11 PJ=2.45314e-05 nf=1
D136 VSSC VSSO dpnwcpl18 AREA=1.642e-11 PJ=2.45314e-05 nf=1
D137 VSSC VSSO dpnwcpl18 AREA=1.642e-11 PJ=2.45314e-05 nf=1
D138 VSSC VSS dpnwcpl18 AREA=1.642e-11 PJ=2.45314e-05 nf=1
D139 VSSC VSS dpnwcpl18 AREA=1.642e-11 PJ=2.45314e-05 nf=1
D140 VSSC VSS dpnwcpl18 AREA=1.642e-11 PJ=2.45314e-05 nf=1
D141 VSSC VSS dpnwcpl18 AREA=1.642e-11 PJ=2.45314e-05 nf=1
D142 VSSC VSS dpnwcpl18 AREA=1.642e-11 PJ=2.45314e-05 nf=1
D143 VSSC VSS dpnwcpl18 AREA=1.642e-11 PJ=2.45314e-05 nf=1
D144 VSSC VSS dpnwcpl18 AREA=1.642e-11 PJ=2.45314e-05 nf=1
D145 VSSC VSS dpnwcpl18 AREA=1.642e-11 PJ=2.45314e-05 nf=1
D146 VSSC VSS dpnwcpl18 AREA=1.642e-11 PJ=2.45314e-05 nf=1
.ENDS

.SUBCKT PVDC_NA_NA_50 VDDC VDDO VSSO VSS VDD VSSC
*.PININFO VDDC:B VDDO:B VSSO:B VSS:B VDD:B VSSC:B
M0 8 VDDC 8 VSSO N5 L=4.55e-06 W=5.5e-06 rf_flag=0
M1 8 VDDC 8 VSSO N5 L=4.55e-06 W=5.5e-06 rf_flag=0
M2 8 VDDC 8 VSSO N5 L=4.55e-06 W=5.5e-06 rf_flag=0
M3 8 VDDC 8 VSSO N5 L=4.55e-06 W=5.5e-06 rf_flag=0
M4 8 VDDC 8 VSSO N5 L=4.55e-06 W=5.5e-06 rf_flag=0
M5 8 VDDC 8 VSSO N5 L=4.55e-06 W=5.5e-06 rf_flag=0
M6 8 VDDC 8 VSSO N5 L=4.55e-06 W=5.5e-06 rf_flag=0
M7 8 VDDC 8 VSSO N5 L=4.55e-06 W=5.5e-06 rf_flag=0
M8 8 VDDC 8 VSSO N5 L=4.55e-06 W=5.5e-06 rf_flag=0
M9 8 VDDC 8 VSSO N5 L=4.55e-06 W=5.5e-06 rf_flag=0
M10 9 VDDC 9 VSS N5 L=4.55e-06 W=5.5e-06 rf_flag=0
M11 9 VDDC 9 VSS N5 L=4.55e-06 W=5.5e-06 rf_flag=0
M12 9 VDDC 9 VSS N5 L=4.55e-06 W=5.5e-06 rf_flag=0
M13 9 VDDC 9 VSS N5 L=4.55e-06 W=5.5e-06 rf_flag=0
M14 9 VDDC 9 VSS N5 L=4.55e-06 W=5.5e-06 rf_flag=0
M15 9 VDDC 9 VSS N5 L=4.55e-06 W=5.5e-06 rf_flag=0
M16 9 VDDC 9 VSS N5 L=4.55e-06 W=5.5e-06 rf_flag=0
M17 9 VDDC 9 VSS N5 L=4.55e-06 W=5.5e-06 rf_flag=0
M18 9 VDDC 9 VSS N5 L=4.55e-06 W=5.5e-06 rf_flag=0
M19 9 VDDC 9 VSS N5 L=4.55e-06 W=5.5e-06 rf_flag=0
M20 10 VDDC 10 VSSC N5 L=4.55e-06 W=5.5e-06 rf_flag=0
M21 10 VDDC 10 VSSC N5 L=4.55e-06 W=5.5e-06 rf_flag=0
M22 10 VDDC 10 VSSC N5 L=4.55e-06 W=5.5e-06 rf_flag=0
M23 10 VDDC 10 VSSC N5 L=4.55e-06 W=5.5e-06 rf_flag=0
M24 10 VDDC 10 VSSC N5 L=4.55e-06 W=5.5e-06 rf_flag=0
M25 10 VDDC 10 VSSC N5 L=4.55e-06 W=5.5e-06 rf_flag=0
M26 10 VDDC 10 VSSC N5 L=4.55e-06 W=5.5e-06 rf_flag=0
M27 10 VDDC 10 VSSC N5 L=4.55e-06 W=5.5e-06 rf_flag=0
M28 10 VDDC 10 VSSC N5 L=4.55e-06 W=5.5e-06 rf_flag=0
M29 10 VDDC 10 VSSC N5 L=4.55e-06 W=5.5e-06 rf_flag=0
R30 VSSO 6 8325.14 L=4e-05 W=2e-06 postlayout=1 $SUB=VSSO $[RE3]
R31 7 VSS 8325.14 L=4e-05 W=2e-06 postlayout=1 $SUB=VSS $[RE3]
R32 8 6 8325.14 L=4e-05 W=2e-06 postlayout=1 $SUB=VSSO $[RE3]
R33 7 9 8325.14 L=4e-05 W=2e-06 postlayout=1 $SUB=VSS $[RE3]
R34 10 11 8325.14 L=4e-05 W=2e-06 postlayout=1 $SUB=VSSC $[RE3]
R35 VSSC 11 8325.14 L=4e-05 W=2e-06 postlayout=1 $SUB=VSSC $[RE3]
D36 VSSO VDDC dwn2psub AREA=3.82719e-09 PJ=0.00269537
D37 VSS VDDC dwn2psub AREA=3.82719e-09 PJ=0.00269537
D38 VSSO VDDC dwn2psub AREA=3.82719e-09 PJ=0.00269537
D39 VSS VDDC dwn2psub AREA=3.82719e-09 PJ=0.00269537
D40 VSSC VDDC dwn2psub AREA=3.82719e-09 PJ=0.00269537
D41 VSSO VDDC dwn2psub AREA=3.82719e-09 PJ=0.00269537
D42 VSS VDDC dwn2psub AREA=3.82719e-09 PJ=0.00269537
D43 VSSO VSSC dwn2psub AREA=6.3409e-10 PJ=0.00011544
D44 VSS VSSC dwn2psub AREA=6.3409e-10 PJ=0.00011544
D45 VSSO VDDC dwn2psub AREA=3.82719e-09 PJ=0.00269537
D46 VSS VDDC dwn2psub AREA=3.82719e-09 PJ=0.00269537
D47 VSSO VSSO dwn2psub AREA=6.3409e-10 PJ=0.00011544
D48 VSS VSS dwn2psub AREA=6.3409e-10 PJ=0.00011544
D49 VSSC VDDC dwn2psub AREA=3.82719e-09 PJ=0.00269537
D50 VSS VDDC dwn2psub AREA=3.82719e-09 PJ=0.00269537
M51 VDDC 8 VSSO VSSO n5pcesd L=6e-07 W=2.5e-05
M52 VSSO 8 VDDC VSSO n5pcesd L=6e-07 W=2.5e-05
M53 VDDC 8 VSSO VSSO n5pcesd L=6e-07 W=2.5e-05
M54 VSSO 8 VDDC VSSO n5pcesd L=6e-07 W=2.5e-05
M55 VDDC 8 VSSO VSSO n5pcesd L=6e-07 W=2.5e-05
M56 VSSO 8 VDDC VSSO n5pcesd L=6e-07 W=2.5e-05
M57 VDDC 8 VSSO VSSO n5pcesd L=6e-07 W=2.5e-05
M58 VSSO 8 VDDC VSSO n5pcesd L=6e-07 W=2.5e-05
M59 VDDC 8 VSSO VSSO n5pcesd L=6e-07 W=2.5e-05
M60 VSSO 8 VDDC VSSO n5pcesd L=6e-07 W=2.5e-05
M61 VDDC 8 VSSO VSSO n5pcesd L=6e-07 W=2.5e-05
M62 VSSO 8 VDDC VSSO n5pcesd L=6e-07 W=2.5e-05
M63 VDDC 8 VSSO VSSO n5pcesd L=6e-07 W=2.5e-05
M64 VSSO 8 VDDC VSSO n5pcesd L=6e-07 W=2.5e-05
M65 VDDC 8 VSSO VSSO n5pcesd L=6e-07 W=2.5e-05
M66 VSSO 8 VDDC VSSO n5pcesd L=6e-07 W=2.5e-05
M67 VDDC 8 VSSO VSSO n5pcesd L=6e-07 W=2.5e-05
M68 VSSO 8 VDDC VSSO n5pcesd L=6e-07 W=2.5e-05
M69 VDDC 8 VSSO VSSO n5pcesd L=6e-07 W=2.5e-05
M70 VSSO 8 VDDC VSSO n5pcesd L=6e-07 W=2.5e-05
M71 VDDC 9 VSS VSS n5pcesd L=6e-07 W=2.5e-05
M72 VSS 9 VDDC VSS n5pcesd L=6e-07 W=2.5e-05
M73 VDDC 9 VSS VSS n5pcesd L=6e-07 W=2.5e-05
M74 VSS 9 VDDC VSS n5pcesd L=6e-07 W=2.5e-05
M75 VDDC 9 VSS VSS n5pcesd L=6e-07 W=2.5e-05
M76 VSS 9 VDDC VSS n5pcesd L=6e-07 W=2.5e-05
M77 VDDC 9 VSS VSS n5pcesd L=6e-07 W=2.5e-05
M78 VSS 9 VDDC VSS n5pcesd L=6e-07 W=2.5e-05
M79 VDDC 9 VSS VSS n5pcesd L=6e-07 W=2.5e-05
M80 VSS 9 VDDC VSS n5pcesd L=6e-07 W=2.5e-05
M81 VDDC 9 VSS VSS n5pcesd L=6e-07 W=2.5e-05
M82 VSS 9 VDDC VSS n5pcesd L=6e-07 W=2.5e-05
M83 VDDC 9 VSS VSS n5pcesd L=6e-07 W=2.5e-05
M84 VSS 9 VDDC VSS n5pcesd L=6e-07 W=2.5e-05
M85 VDDC 9 VSS VSS n5pcesd L=6e-07 W=2.5e-05
M86 VSS 9 VDDC VSS n5pcesd L=6e-07 W=2.5e-05
M87 VDDC 9 VSS VSS n5pcesd L=6e-07 W=2.5e-05
M88 VSS 9 VDDC VSS n5pcesd L=6e-07 W=2.5e-05
M89 VDDC 9 VSS VSS n5pcesd L=6e-07 W=2.5e-05
M90 VSS 9 VDDC VSS n5pcesd L=6e-07 W=2.5e-05
M91 VDDC 10 VSSC VSSC n5pcesd L=6e-07 W=2.5e-05
M92 VSSC 10 VDDC VSSC n5pcesd L=6e-07 W=2.5e-05
M93 VDDC 10 VSSC VSSC n5pcesd L=6e-07 W=2.5e-05
M94 VSSC 10 VDDC VSSC n5pcesd L=6e-07 W=2.5e-05
M95 VDDC 10 VSSC VSSC n5pcesd L=6e-07 W=2.5e-05
M96 VSSC 10 VDDC VSSC n5pcesd L=6e-07 W=2.5e-05
M97 VDDC 10 VSSC VSSC n5pcesd L=6e-07 W=2.5e-05
M98 VSSC 10 VDDC VSSC n5pcesd L=6e-07 W=2.5e-05
M99 VDDC 10 VSSC VSSC n5pcesd L=6e-07 W=2.5e-05
M100 VSSC 10 VDDC VSSC n5pcesd L=6e-07 W=2.5e-05
M101 VDDC 10 VSSC VSSC n5pcesd L=6e-07 W=2.5e-05
M102 VSSC 10 VDDC VSSC n5pcesd L=6e-07 W=2.5e-05
M103 VDDC 10 VSSC VSSC n5pcesd L=6e-07 W=2.5e-05
M104 VSSC 10 VDDC VSSC n5pcesd L=6e-07 W=2.5e-05
M105 VDDC 10 VSSC VSSC n5pcesd L=6e-07 W=2.5e-05
M106 VSSC 10 VDDC VSSC n5pcesd L=6e-07 W=2.5e-05
M107 VDDC 10 VSSC VSSC n5pcesd L=6e-07 W=2.5e-05
M108 VSSC 10 VDDC VSSC n5pcesd L=6e-07 W=2.5e-05
M109 VDDC 10 VSSC VSSC n5pcesd L=6e-07 W=2.5e-05
M110 VSSC 10 VDDC VSSC n5pcesd L=6e-07 W=2.5e-05
D111 VSSO VSSC dpnwcpl5 AREA=1.642e-11 PJ=2.45314e-05 nf=1
D112 VSSO VSSC dpnwcpl5 AREA=1.642e-11 PJ=2.45314e-05 nf=1
D113 VSSO VSSC dpnwcpl5 AREA=1.642e-11 PJ=2.45314e-05 nf=1
D114 VSSO VSSC dpnwcpl5 AREA=1.642e-11 PJ=2.45314e-05 nf=1
D115 VSSO VSSC dpnwcpl5 AREA=1.642e-11 PJ=2.45314e-05 nf=1
D116 VSSO VSSC dpnwcpl5 AREA=1.642e-11 PJ=2.45314e-05 nf=1
D117 VSSO VSSC dpnwcpl5 AREA=1.642e-11 PJ=2.45314e-05 nf=1
D118 VSSO VSSC dpnwcpl5 AREA=1.642e-11 PJ=2.45314e-05 nf=1
D119 VSSO VSSC dpnwcpl5 AREA=1.642e-11 PJ=2.45314e-05 nf=1
D120 VSS VSSC dpnwcpl5 AREA=1.642e-11 PJ=2.45314e-05 nf=1
D121 VSS VSSC dpnwcpl5 AREA=1.642e-11 PJ=2.45314e-05 nf=1
D122 VSS VSSC dpnwcpl5 AREA=1.642e-11 PJ=2.45314e-05 nf=1
D123 VSS VSSC dpnwcpl5 AREA=1.642e-11 PJ=2.45314e-05 nf=1
D124 VSS VSSC dpnwcpl5 AREA=1.642e-11 PJ=2.45314e-05 nf=1
D125 VSS VSSC dpnwcpl5 AREA=1.642e-11 PJ=2.45314e-05 nf=1
D126 VSS VSSC dpnwcpl5 AREA=1.642e-11 PJ=2.45314e-05 nf=1
D127 VSS VSSC dpnwcpl5 AREA=1.642e-11 PJ=2.45314e-05 nf=1
D128 VSS VSSC dpnwcpl5 AREA=1.642e-11 PJ=2.45314e-05 nf=1
D129 VSSC VSSO dpnwcpl5 AREA=1.642e-11 PJ=2.45314e-05 nf=1
D130 VSSC VSSO dpnwcpl5 AREA=1.642e-11 PJ=2.45314e-05 nf=1
D131 VSSC VSSO dpnwcpl5 AREA=1.642e-11 PJ=2.45314e-05 nf=1
D132 VSSC VSSO dpnwcpl5 AREA=1.642e-11 PJ=2.45314e-05 nf=1
D133 VSSC VSSO dpnwcpl5 AREA=1.642e-11 PJ=2.45314e-05 nf=1
D134 VSSC VSSO dpnwcpl5 AREA=1.642e-11 PJ=2.45314e-05 nf=1
D135 VSSC VSSO dpnwcpl5 AREA=1.642e-11 PJ=2.45314e-05 nf=1
D136 VSSC VSSO dpnwcpl5 AREA=1.642e-11 PJ=2.45314e-05 nf=1
D137 VSSC VSSO dpnwcpl5 AREA=1.642e-11 PJ=2.45314e-05 nf=1
D138 VSSC VSS dpnwcpl5 AREA=1.642e-11 PJ=2.45314e-05 nf=1
D139 VSSC VSS dpnwcpl5 AREA=1.642e-11 PJ=2.45314e-05 nf=1
D140 VSSC VSS dpnwcpl5 AREA=1.642e-11 PJ=2.45314e-05 nf=1
D141 VSSC VSS dpnwcpl5 AREA=1.642e-11 PJ=2.45314e-05 nf=1
D142 VSSC VSS dpnwcpl5 AREA=1.642e-11 PJ=2.45314e-05 nf=1
D143 VSSC VSS dpnwcpl5 AREA=1.642e-11 PJ=2.45314e-05 nf=1
D144 VSSC VSS dpnwcpl5 AREA=1.642e-11 PJ=2.45314e-05 nf=1
D145 VSSC VSS dpnwcpl5 AREA=1.642e-11 PJ=2.45314e-05 nf=1
D146 VSSC VSS dpnwcpl5 AREA=1.642e-11 PJ=2.45314e-05 nf=1
.ENDS

.SUBCKT PVDF_18_18 VDDO VSSO VSS VDD
*.PININFO VDDO:B VSSO:B VSS:B VDD:B
M0 6 VDDO 6 VSSO N L=4.55e-06 W=5.5e-06 rf_flag=0
M1 6 VDDO 6 VSSO N L=4.55e-06 W=5.5e-06 rf_flag=0
M2 6 VDDO 6 VSSO N L=4.55e-06 W=5.5e-06 rf_flag=0
M3 6 VDDO 6 VSSO N L=4.55e-06 W=5.5e-06 rf_flag=0
M4 6 VDDO 6 VSSO N L=4.55e-06 W=5.5e-06 rf_flag=0
M5 6 VDDO 6 VSSO N L=4.55e-06 W=5.5e-06 rf_flag=0
M6 6 VDDO 6 VSSO N L=4.55e-06 W=5.5e-06 rf_flag=0
M7 6 VDDO 6 VSSO N L=4.55e-06 W=5.5e-06 rf_flag=0
M8 6 VDDO 6 VSSO N L=4.55e-06 W=5.5e-06 rf_flag=0
M9 6 VDDO 6 VSSO N L=4.55e-06 W=5.5e-06 rf_flag=0
M10 7 VDDO 7 VSS N L=4.55e-06 W=5.5e-06 rf_flag=0
M11 7 VDDO 7 VSS N L=4.55e-06 W=5.5e-06 rf_flag=0
M12 7 VDDO 7 VSS N L=4.55e-06 W=5.5e-06 rf_flag=0
M13 7 VDDO 7 VSS N L=4.55e-06 W=5.5e-06 rf_flag=0
M14 7 VDDO 7 VSS N L=4.55e-06 W=5.5e-06 rf_flag=0
M15 7 VDDO 7 VSS N L=4.55e-06 W=5.5e-06 rf_flag=0
M16 7 VDDO 7 VSS N L=4.55e-06 W=5.5e-06 rf_flag=0
M17 7 VDDO 7 VSS N L=4.55e-06 W=5.5e-06 rf_flag=0
M18 7 VDDO 7 VSS N L=4.55e-06 W=5.5e-06 rf_flag=0
M19 7 VDDO 7 VSS N L=4.55e-06 W=5.5e-06 rf_flag=0
R20 VSSO 4 8325.14 L=4e-05 W=2e-06 postlayout=1 $SUB=VSSO $[RE3]
R21 VSS 5 8325.14 L=4e-05 W=2e-06 postlayout=1 $SUB=VSS $[RE3]
R22 6 4 8325.14 L=4e-05 W=2e-06 postlayout=1 $SUB=VSSO $[RE3]
R23 7 5 8325.14 L=4e-05 W=2e-06 postlayout=1 $SUB=VSS $[RE3]
D24 VSS VDDO dwn2psub AREA=8.1825e-10 PJ=0.00081425
D25 VSS VDDO dwn2psub AREA=8.1825e-10 PJ=0.00081425
D26 VSSO VDDO dwn2psub AREA=8.1825e-10 PJ=0.00081425
D27 VSS VDDO dwn2psub AREA=8.1825e-10 PJ=0.00081425
D28 VSSO VDDO dwn2psub AREA=8.1825e-10 PJ=0.00081425
D29 VSS VDDO dwn2psub AREA=8.1825e-10 PJ=0.00081425
M30 VSSO 6 VDDO VSSO n18pcesd L=2.5e-07 W=2.5e-05
M31 VDDO 6 VSSO VSSO n18pcesd L=2.5e-07 W=2.5e-05
M32 VSSO 6 VDDO VSSO n18pcesd L=2.5e-07 W=2.5e-05
M33 VDDO 6 VSSO VSSO n18pcesd L=2.5e-07 W=2.5e-05
M34 VSSO 6 VDDO VSSO n18pcesd L=2.5e-07 W=2.5e-05
M35 VDDO 6 VSSO VSSO n18pcesd L=2.5e-07 W=2.5e-05
M36 VSSO 6 VDDO VSSO n18pcesd L=2.5e-07 W=2.5e-05
M37 VDDO 6 VSSO VSSO n18pcesd L=2.5e-07 W=2.5e-05
M38 VSSO 6 VDDO VSSO n18pcesd L=2.5e-07 W=2.5e-05
M39 VDDO 6 VSSO VSSO n18pcesd L=2.5e-07 W=2.5e-05
M40 VSSO 6 VDDO VSSO n18pcesd L=2.5e-07 W=2.5e-05
M41 VDDO 6 VSSO VSSO n18pcesd L=2.5e-07 W=2.5e-05
M42 VSSO 6 VDDO VSSO n18pcesd L=2.5e-07 W=2.5e-05
M43 VDDO 6 VSSO VSSO n18pcesd L=2.5e-07 W=2.5e-05
M44 VSSO 6 VDDO VSSO n18pcesd L=2.5e-07 W=2.5e-05
M45 VDDO 6 VSSO VSSO n18pcesd L=2.5e-07 W=2.5e-05
M46 VSSO 6 VDDO VSSO n18pcesd L=2.5e-07 W=2.5e-05
M47 VDDO 6 VSSO VSSO n18pcesd L=2.5e-07 W=2.5e-05
M48 VSSO 6 VDDO VSSO n18pcesd L=2.5e-07 W=2.5e-05
M49 VDDO 6 VSSO VSSO n18pcesd L=2.5e-07 W=2.5e-05
M50 VSS 7 VDDO VSS n18pcesd L=2.5e-07 W=2.5e-05
M51 VDDO 7 VSS VSS n18pcesd L=2.5e-07 W=2.5e-05
M52 VSS 7 VDDO VSS n18pcesd L=2.5e-07 W=2.5e-05
M53 VDDO 7 VSS VSS n18pcesd L=2.5e-07 W=2.5e-05
M54 VSS 7 VDDO VSS n18pcesd L=2.5e-07 W=2.5e-05
M55 VDDO 7 VSS VSS n18pcesd L=2.5e-07 W=2.5e-05
M56 VSS 7 VDDO VSS n18pcesd L=2.5e-07 W=2.5e-05
M57 VDDO 7 VSS VSS n18pcesd L=2.5e-07 W=2.5e-05
M58 VSS 7 VDDO VSS n18pcesd L=2.5e-07 W=2.5e-05
M59 VDDO 7 VSS VSS n18pcesd L=2.5e-07 W=2.5e-05
M60 VSS 7 VDDO VSS n18pcesd L=2.5e-07 W=2.5e-05
M61 VDDO 7 VSS VSS n18pcesd L=2.5e-07 W=2.5e-05
M62 VSS 7 VDDO VSS n18pcesd L=2.5e-07 W=2.5e-05
M63 VDDO 7 VSS VSS n18pcesd L=2.5e-07 W=2.5e-05
M64 VSS 7 VDDO VSS n18pcesd L=2.5e-07 W=2.5e-05
M65 VDDO 7 VSS VSS n18pcesd L=2.5e-07 W=2.5e-05
M66 VSS 7 VDDO VSS n18pcesd L=2.5e-07 W=2.5e-05
M67 VDDO 7 VSS VSS n18pcesd L=2.5e-07 W=2.5e-05
M68 VSS 7 VDDO VSS n18pcesd L=2.5e-07 W=2.5e-05
M69 VDDO 7 VSS VSS n18pcesd L=2.5e-07 W=2.5e-05
.ENDS

.SUBCKT PVDF_50_50 VDDO VSSO VSS VDD
*.PININFO VDDO:B VSSO:B VSS:B VDD:B
M0 6 VDDO 6 VSSO N5 L=4.55e-06 W=5.5e-06 rf_flag=0
M1 6 VDDO 6 VSSO N5 L=4.55e-06 W=5.5e-06 rf_flag=0
M2 6 VDDO 6 VSSO N5 L=4.55e-06 W=5.5e-06 rf_flag=0
M3 6 VDDO 6 VSSO N5 L=4.55e-06 W=5.5e-06 rf_flag=0
M4 6 VDDO 6 VSSO N5 L=4.55e-06 W=5.5e-06 rf_flag=0
M5 6 VDDO 6 VSSO N5 L=4.55e-06 W=5.5e-06 rf_flag=0
M6 6 VDDO 6 VSSO N5 L=4.55e-06 W=5.5e-06 rf_flag=0
M7 6 VDDO 6 VSSO N5 L=4.55e-06 W=5.5e-06 rf_flag=0
M8 6 VDDO 6 VSSO N5 L=4.55e-06 W=5.5e-06 rf_flag=0
M9 6 VDDO 6 VSSO N5 L=4.55e-06 W=5.5e-06 rf_flag=0
M10 7 VDDO 7 VSS N5 L=4.55e-06 W=5.5e-06 rf_flag=0
M11 7 VDDO 7 VSS N5 L=4.55e-06 W=5.5e-06 rf_flag=0
M12 7 VDDO 7 VSS N5 L=4.55e-06 W=5.5e-06 rf_flag=0
M13 7 VDDO 7 VSS N5 L=4.55e-06 W=5.5e-06 rf_flag=0
M14 7 VDDO 7 VSS N5 L=4.55e-06 W=5.5e-06 rf_flag=0
M15 7 VDDO 7 VSS N5 L=4.55e-06 W=5.5e-06 rf_flag=0
M16 7 VDDO 7 VSS N5 L=4.55e-06 W=5.5e-06 rf_flag=0
M17 7 VDDO 7 VSS N5 L=4.55e-06 W=5.5e-06 rf_flag=0
M18 7 VDDO 7 VSS N5 L=4.55e-06 W=5.5e-06 rf_flag=0
M19 7 VDDO 7 VSS N5 L=4.55e-06 W=5.5e-06 rf_flag=0
R20 VSSO 4 8325.14 L=4e-05 W=2e-06 postlayout=1 $SUB=VSSO $[RE3]
R21 VSS 5 8325.14 L=4e-05 W=2e-06 postlayout=1 $SUB=VSS $[RE3]
R22 6 4 8325.14 L=4e-05 W=2e-06 postlayout=1 $SUB=VSSO $[RE3]
R23 7 5 8325.14 L=4e-05 W=2e-06 postlayout=1 $SUB=VSS $[RE3]
D24 VSS VDDO dwn2psub AREA=8.1825e-10 PJ=0.00081425
D25 VSS VDDO dwn2psub AREA=8.1825e-10 PJ=0.00081425
D26 VSSO VDDO dwn2psub AREA=8.1825e-10 PJ=0.00081425
D27 VSS VDDO dwn2psub AREA=8.1825e-10 PJ=0.00081425
D28 VSSO VDDO dwn2psub AREA=8.1825e-10 PJ=0.00081425
D29 VSS VDDO dwn2psub AREA=8.1825e-10 PJ=0.00081425
M30 VSSO 6 VDDO VSSO n5pcesd L=6e-07 W=2.5e-05
M31 VDDO 6 VSSO VSSO n5pcesd L=6e-07 W=2.5e-05
M32 VSSO 6 VDDO VSSO n5pcesd L=6e-07 W=2.5e-05
M33 VDDO 6 VSSO VSSO n5pcesd L=6e-07 W=2.5e-05
M34 VSSO 6 VDDO VSSO n5pcesd L=6e-07 W=2.5e-05
M35 VDDO 6 VSSO VSSO n5pcesd L=6e-07 W=2.5e-05
M36 VSSO 6 VDDO VSSO n5pcesd L=6e-07 W=2.5e-05
M37 VDDO 6 VSSO VSSO n5pcesd L=6e-07 W=2.5e-05
M38 VSSO 6 VDDO VSSO n5pcesd L=6e-07 W=2.5e-05
M39 VDDO 6 VSSO VSSO n5pcesd L=6e-07 W=2.5e-05
M40 VSSO 6 VDDO VSSO n5pcesd L=6e-07 W=2.5e-05
M41 VDDO 6 VSSO VSSO n5pcesd L=6e-07 W=2.5e-05
M42 VSSO 6 VDDO VSSO n5pcesd L=6e-07 W=2.5e-05
M43 VDDO 6 VSSO VSSO n5pcesd L=6e-07 W=2.5e-05
M44 VSSO 6 VDDO VSSO n5pcesd L=6e-07 W=2.5e-05
M45 VDDO 6 VSSO VSSO n5pcesd L=6e-07 W=2.5e-05
M46 VSSO 6 VDDO VSSO n5pcesd L=6e-07 W=2.5e-05
M47 VDDO 6 VSSO VSSO n5pcesd L=6e-07 W=2.5e-05
M48 VSSO 6 VDDO VSSO n5pcesd L=6e-07 W=2.5e-05
M49 VDDO 6 VSSO VSSO n5pcesd L=6e-07 W=2.5e-05
M50 VSS 7 VDDO VSS n5pcesd L=6e-07 W=2.5e-05
M51 VDDO 7 VSS VSS n5pcesd L=6e-07 W=2.5e-05
M52 VSS 7 VDDO VSS n5pcesd L=6e-07 W=2.5e-05
M53 VDDO 7 VSS VSS n5pcesd L=6e-07 W=2.5e-05
M54 VSS 7 VDDO VSS n5pcesd L=6e-07 W=2.5e-05
M55 VDDO 7 VSS VSS n5pcesd L=6e-07 W=2.5e-05
M56 VSS 7 VDDO VSS n5pcesd L=6e-07 W=2.5e-05
M57 VDDO 7 VSS VSS n5pcesd L=6e-07 W=2.5e-05
M58 VSS 7 VDDO VSS n5pcesd L=6e-07 W=2.5e-05
M59 VDDO 7 VSS VSS n5pcesd L=6e-07 W=2.5e-05
M60 VSS 7 VDDO VSS n5pcesd L=6e-07 W=2.5e-05
M61 VDDO 7 VSS VSS n5pcesd L=6e-07 W=2.5e-05
M62 VSS 7 VDDO VSS n5pcesd L=6e-07 W=2.5e-05
M63 VDDO 7 VSS VSS n5pcesd L=6e-07 W=2.5e-05
M64 VSS 7 VDDO VSS n5pcesd L=6e-07 W=2.5e-05
M65 VDDO 7 VSS VSS n5pcesd L=6e-07 W=2.5e-05
M66 VSS 7 VDDO VSS n5pcesd L=6e-07 W=2.5e-05
M67 VDDO 7 VSS VSS n5pcesd L=6e-07 W=2.5e-05
M68 VSS 7 VDDO VSS n5pcesd L=6e-07 W=2.5e-05
M69 VDDO 7 VSS VSS n5pcesd L=6e-07 W=2.5e-05
.ENDS

.SUBCKT PVDI_NA_18 VDD VDDO VSSO VSS
*.PININFO VDD:B VDDO:B VSSO:B VSS:B
M0 6 VDD 6 VSS N L=4.55e-06 W=5.5e-06 rf_flag=0
M1 6 VDD 6 VSS N L=4.55e-06 W=5.5e-06 rf_flag=0
M2 6 VDD 6 VSS N L=4.55e-06 W=5.5e-06 rf_flag=0
M3 6 VDD 6 VSS N L=4.55e-06 W=5.5e-06 rf_flag=0
M4 6 VDD 6 VSS N L=4.55e-06 W=5.5e-06 rf_flag=0
M5 6 VDD 6 VSS N L=4.55e-06 W=5.5e-06 rf_flag=0
M6 6 VDD 6 VSS N L=4.55e-06 W=5.5e-06 rf_flag=0
M7 6 VDD 6 VSS N L=4.55e-06 W=5.5e-06 rf_flag=0
M8 6 VDD 6 VSS N L=4.55e-06 W=5.5e-06 rf_flag=0
M9 6 VDD 6 VSS N L=4.55e-06 W=5.5e-06 rf_flag=0
M10 7 VDD 7 VSSO N L=4.55e-06 W=5.5e-06 rf_flag=0
M11 7 VDD 7 VSSO N L=4.55e-06 W=5.5e-06 rf_flag=0
M12 7 VDD 7 VSSO N L=4.55e-06 W=5.5e-06 rf_flag=0
M13 7 VDD 7 VSSO N L=4.55e-06 W=5.5e-06 rf_flag=0
M14 7 VDD 7 VSSO N L=4.55e-06 W=5.5e-06 rf_flag=0
M15 7 VDD 7 VSSO N L=4.55e-06 W=5.5e-06 rf_flag=0
M16 7 VDD 7 VSSO N L=4.55e-06 W=5.5e-06 rf_flag=0
M17 7 VDD 7 VSSO N L=4.55e-06 W=5.5e-06 rf_flag=0
M18 7 VDD 7 VSSO N L=4.55e-06 W=5.5e-06 rf_flag=0
M19 7 VDD 7 VSSO N L=4.55e-06 W=5.5e-06 rf_flag=0
R20 VSS 5 8325.14 L=4e-05 W=2e-06 postlayout=1 $SUB=VSS $[RE3]
R21 6 5 8325.14 L=4e-05 W=2e-06 postlayout=1 $SUB=VSS $[RE3]
R22 7 8 8325.14 L=4e-05 W=2e-06 postlayout=1 $SUB=VSSO $[RE3]
R23 VSSO 8 8325.14 L=4e-05 W=2e-06 postlayout=1 $SUB=VSSO $[RE3]
D24 VSS VDD dwn2psub AREA=1.4208e-09 PJ=0.0014088
D25 VSS VDD dwn2psub AREA=1.4208e-09 PJ=0.0014088
D26 VSS VDD dwn2psub AREA=2.9452e-10 PJ=0.00029452
D27 VSSO VDD dwn2psub AREA=2.9452e-10 PJ=0.00029452
D28 VSSO VSS dwn2psub AREA=6.3409e-10 PJ=0.00011544
D29 VSS VDD dwn2psub AREA=1.4208e-09 PJ=0.0014088
D30 VSSO VDD dwn2psub AREA=1.4208e-09 PJ=0.0014088
D31 VSS VDD dwn2psub AREA=2.9452e-10 PJ=0.00029452
D32 VSS VDD dwn2psub AREA=2.9452e-10 PJ=0.00029452
D33 VSS VSSO dwn2psub AREA=6.3409e-10 PJ=0.00011544
D34 VSSO VDD dwn2psub AREA=1.4208e-09 PJ=0.0014088
M35 VDD 6 VSS VSS n18pcesd L=2.5e-07 W=2.5e-05
M36 VSS 6 VDD VSS n18pcesd L=2.5e-07 W=2.5e-05
M37 VDD 6 VSS VSS n18pcesd L=2.5e-07 W=2.5e-05
M38 VSS 6 VDD VSS n18pcesd L=2.5e-07 W=2.5e-05
M39 VDD 6 VSS VSS n18pcesd L=2.5e-07 W=2.5e-05
M40 VSS 6 VDD VSS n18pcesd L=2.5e-07 W=2.5e-05
M41 VDD 6 VSS VSS n18pcesd L=2.5e-07 W=2.5e-05
M42 VSS 6 VDD VSS n18pcesd L=2.5e-07 W=2.5e-05
M43 VDD 6 VSS VSS n18pcesd L=2.5e-07 W=2.5e-05
M44 VSS 6 VDD VSS n18pcesd L=2.5e-07 W=2.5e-05
M45 VDD 6 VSS VSS n18pcesd L=2.5e-07 W=2.5e-05
M46 VSS 6 VDD VSS n18pcesd L=2.5e-07 W=2.5e-05
M47 VDD 6 VSS VSS n18pcesd L=2.5e-07 W=2.5e-05
M48 VSS 6 VDD VSS n18pcesd L=2.5e-07 W=2.5e-05
M49 VDD 6 VSS VSS n18pcesd L=2.5e-07 W=2.5e-05
M50 VSS 6 VDD VSS n18pcesd L=2.5e-07 W=2.5e-05
M51 VDD 6 VSS VSS n18pcesd L=2.5e-07 W=2.5e-05
M52 VSS 6 VDD VSS n18pcesd L=2.5e-07 W=2.5e-05
M53 VDD 6 VSS VSS n18pcesd L=2.5e-07 W=2.5e-05
M54 VSS 6 VDD VSS n18pcesd L=2.5e-07 W=2.5e-05
M55 VDD 7 VSSO VSSO n18pcesd L=2.5e-07 W=2.5e-05
M56 VSSO 7 VDD VSSO n18pcesd L=2.5e-07 W=2.5e-05
M57 VDD 7 VSSO VSSO n18pcesd L=2.5e-07 W=2.5e-05
M58 VSSO 7 VDD VSSO n18pcesd L=2.5e-07 W=2.5e-05
M59 VDD 7 VSSO VSSO n18pcesd L=2.5e-07 W=2.5e-05
M60 VSSO 7 VDD VSSO n18pcesd L=2.5e-07 W=2.5e-05
M61 VDD 7 VSSO VSSO n18pcesd L=2.5e-07 W=2.5e-05
M62 VSSO 7 VDD VSSO n18pcesd L=2.5e-07 W=2.5e-05
M63 VDD 7 VSSO VSSO n18pcesd L=2.5e-07 W=2.5e-05
M64 VSSO 7 VDD VSSO n18pcesd L=2.5e-07 W=2.5e-05
M65 VDD 7 VSSO VSSO n18pcesd L=2.5e-07 W=2.5e-05
M66 VSSO 7 VDD VSSO n18pcesd L=2.5e-07 W=2.5e-05
M67 VDD 7 VSSO VSSO n18pcesd L=2.5e-07 W=2.5e-05
M68 VSSO 7 VDD VSSO n18pcesd L=2.5e-07 W=2.5e-05
M69 VDD 7 VSSO VSSO n18pcesd L=2.5e-07 W=2.5e-05
M70 VSSO 7 VDD VSSO n18pcesd L=2.5e-07 W=2.5e-05
M71 VDD 7 VSSO VSSO n18pcesd L=2.5e-07 W=2.5e-05
M72 VSSO 7 VDD VSSO n18pcesd L=2.5e-07 W=2.5e-05
M73 VDD 7 VSSO VSSO n18pcesd L=2.5e-07 W=2.5e-05
M74 VSSO 7 VDD VSSO n18pcesd L=2.5e-07 W=2.5e-05
D75 VSSO VSS dpnwcpl18 AREA=1.642e-11 PJ=2.45314e-05 nf=1
D76 VSSO VSS dpnwcpl18 AREA=1.642e-11 PJ=2.45314e-05 nf=1
D77 VSSO VSS dpnwcpl18 AREA=1.642e-11 PJ=2.45314e-05 nf=1
D78 VSSO VSS dpnwcpl18 AREA=1.642e-11 PJ=2.45314e-05 nf=1
D79 VSSO VSS dpnwcpl18 AREA=1.642e-11 PJ=2.45314e-05 nf=1
D80 VSSO VSS dpnwcpl18 AREA=1.642e-11 PJ=2.45314e-05 nf=1
D81 VSSO VSS dpnwcpl18 AREA=1.642e-11 PJ=2.45314e-05 nf=1
D82 VSSO VSS dpnwcpl18 AREA=1.642e-11 PJ=2.45314e-05 nf=1
D83 VSSO VSS dpnwcpl18 AREA=1.642e-11 PJ=2.45314e-05 nf=1
D84 VSS VSSO dpnwcpl18 AREA=1.642e-11 PJ=2.45314e-05 nf=1
D85 VSS VSSO dpnwcpl18 AREA=1.642e-11 PJ=2.45314e-05 nf=1
D86 VSS VSSO dpnwcpl18 AREA=1.642e-11 PJ=2.45314e-05 nf=1
D87 VSS VSSO dpnwcpl18 AREA=1.642e-11 PJ=2.45314e-05 nf=1
D88 VSS VSSO dpnwcpl18 AREA=1.642e-11 PJ=2.45314e-05 nf=1
D89 VSS VSSO dpnwcpl18 AREA=1.642e-11 PJ=2.45314e-05 nf=1
D90 VSS VSSO dpnwcpl18 AREA=1.642e-11 PJ=2.45314e-05 nf=1
D91 VSS VSSO dpnwcpl18 AREA=1.642e-11 PJ=2.45314e-05 nf=1
D92 VSS VSSO dpnwcpl18 AREA=1.642e-11 PJ=2.45314e-05 nf=1
.ENDS

.SUBCKT PVDI_NA_50 VDD VDDO VSSO VSS
*.PININFO VDD:B VDDO:B VSSO:B VSS:B
M0 6 VDD 6 VSS N5 L=4.55e-06 W=5.5e-06 rf_flag=0
M1 6 VDD 6 VSS N5 L=4.55e-06 W=5.5e-06 rf_flag=0
M2 6 VDD 6 VSS N5 L=4.55e-06 W=5.5e-06 rf_flag=0
M3 6 VDD 6 VSS N5 L=4.55e-06 W=5.5e-06 rf_flag=0
M4 6 VDD 6 VSS N5 L=4.55e-06 W=5.5e-06 rf_flag=0
M5 6 VDD 6 VSS N5 L=4.55e-06 W=5.5e-06 rf_flag=0
M6 6 VDD 6 VSS N5 L=4.55e-06 W=5.5e-06 rf_flag=0
M7 6 VDD 6 VSS N5 L=4.55e-06 W=5.5e-06 rf_flag=0
M8 6 VDD 6 VSS N5 L=4.55e-06 W=5.5e-06 rf_flag=0
M9 6 VDD 6 VSS N5 L=4.55e-06 W=5.5e-06 rf_flag=0
M10 7 VDD 7 VSSO N5 L=4.55e-06 W=5.5e-06 rf_flag=0
M11 7 VDD 7 VSSO N5 L=4.55e-06 W=5.5e-06 rf_flag=0
M12 7 VDD 7 VSSO N5 L=4.55e-06 W=5.5e-06 rf_flag=0
M13 7 VDD 7 VSSO N5 L=4.55e-06 W=5.5e-06 rf_flag=0
M14 7 VDD 7 VSSO N5 L=4.55e-06 W=5.5e-06 rf_flag=0
M15 7 VDD 7 VSSO N5 L=4.55e-06 W=5.5e-06 rf_flag=0
M16 7 VDD 7 VSSO N5 L=4.55e-06 W=5.5e-06 rf_flag=0
M17 7 VDD 7 VSSO N5 L=4.55e-06 W=5.5e-06 rf_flag=0
M18 7 VDD 7 VSSO N5 L=4.55e-06 W=5.5e-06 rf_flag=0
M19 7 VDD 7 VSSO N5 L=4.55e-06 W=5.5e-06 rf_flag=0
R20 VSS 5 8325.14 L=4e-05 W=2e-06 postlayout=1 $SUB=VSS $[RE3]
R21 6 5 8325.14 L=4e-05 W=2e-06 postlayout=1 $SUB=VSS $[RE3]
R22 7 8 8325.14 L=4e-05 W=2e-06 postlayout=1 $SUB=VSSO $[RE3]
R23 VSSO 8 8325.14 L=4e-05 W=2e-06 postlayout=1 $SUB=VSSO $[RE3]
D24 VSS VDD dwn2psub AREA=1.4208e-09 PJ=0.0014088
D25 VSS VDD dwn2psub AREA=1.4208e-09 PJ=0.0014088
D26 VSS VDD dwn2psub AREA=2.9452e-10 PJ=0.00029452
D27 VSSO VDD dwn2psub AREA=2.9452e-10 PJ=0.00029452
D28 VSSO VSS dwn2psub AREA=6.3409e-10 PJ=0.00011544
D29 VSS VDD dwn2psub AREA=1.4208e-09 PJ=0.0014088
D30 VSSO VDD dwn2psub AREA=1.4208e-09 PJ=0.0014088
D31 VSS VDD dwn2psub AREA=2.9452e-10 PJ=0.00029452
D32 VSS VDD dwn2psub AREA=2.9452e-10 PJ=0.00029452
D33 VSS VSSO dwn2psub AREA=6.3409e-10 PJ=0.00011544
D34 VSSO VDD dwn2psub AREA=1.4208e-09 PJ=0.0014088
M35 VDD 6 VSS VSS n5pcesd L=6e-07 W=2.5e-05
M36 VSS 6 VDD VSS n5pcesd L=6e-07 W=2.5e-05
M37 VDD 6 VSS VSS n5pcesd L=6e-07 W=2.5e-05
M38 VSS 6 VDD VSS n5pcesd L=6e-07 W=2.5e-05
M39 VDD 6 VSS VSS n5pcesd L=6e-07 W=2.5e-05
M40 VSS 6 VDD VSS n5pcesd L=6e-07 W=2.5e-05
M41 VDD 6 VSS VSS n5pcesd L=6e-07 W=2.5e-05
M42 VSS 6 VDD VSS n5pcesd L=6e-07 W=2.5e-05
M43 VDD 6 VSS VSS n5pcesd L=6e-07 W=2.5e-05
M44 VSS 6 VDD VSS n5pcesd L=6e-07 W=2.5e-05
M45 VDD 6 VSS VSS n5pcesd L=6e-07 W=2.5e-05
M46 VSS 6 VDD VSS n5pcesd L=6e-07 W=2.5e-05
M47 VDD 6 VSS VSS n5pcesd L=6e-07 W=2.5e-05
M48 VSS 6 VDD VSS n5pcesd L=6e-07 W=2.5e-05
M49 VDD 6 VSS VSS n5pcesd L=6e-07 W=2.5e-05
M50 VSS 6 VDD VSS n5pcesd L=6e-07 W=2.5e-05
M51 VDD 6 VSS VSS n5pcesd L=6e-07 W=2.5e-05
M52 VSS 6 VDD VSS n5pcesd L=6e-07 W=2.5e-05
M53 VDD 6 VSS VSS n5pcesd L=6e-07 W=2.5e-05
M54 VSS 6 VDD VSS n5pcesd L=6e-07 W=2.5e-05
M55 VDD 7 VSSO VSSO n5pcesd L=6e-07 W=2.5e-05
M56 VSSO 7 VDD VSSO n5pcesd L=6e-07 W=2.5e-05
M57 VDD 7 VSSO VSSO n5pcesd L=6e-07 W=2.5e-05
M58 VSSO 7 VDD VSSO n5pcesd L=6e-07 W=2.5e-05
M59 VDD 7 VSSO VSSO n5pcesd L=6e-07 W=2.5e-05
M60 VSSO 7 VDD VSSO n5pcesd L=6e-07 W=2.5e-05
M61 VDD 7 VSSO VSSO n5pcesd L=6e-07 W=2.5e-05
M62 VSSO 7 VDD VSSO n5pcesd L=6e-07 W=2.5e-05
M63 VDD 7 VSSO VSSO n5pcesd L=6e-07 W=2.5e-05
M64 VSSO 7 VDD VSSO n5pcesd L=6e-07 W=2.5e-05
M65 VDD 7 VSSO VSSO n5pcesd L=6e-07 W=2.5e-05
M66 VSSO 7 VDD VSSO n5pcesd L=6e-07 W=2.5e-05
M67 VDD 7 VSSO VSSO n5pcesd L=6e-07 W=2.5e-05
M68 VSSO 7 VDD VSSO n5pcesd L=6e-07 W=2.5e-05
M69 VDD 7 VSSO VSSO n5pcesd L=6e-07 W=2.5e-05
M70 VSSO 7 VDD VSSO n5pcesd L=6e-07 W=2.5e-05
M71 VDD 7 VSSO VSSO n5pcesd L=6e-07 W=2.5e-05
M72 VSSO 7 VDD VSSO n5pcesd L=6e-07 W=2.5e-05
M73 VDD 7 VSSO VSSO n5pcesd L=6e-07 W=2.5e-05
M74 VSSO 7 VDD VSSO n5pcesd L=6e-07 W=2.5e-05
D75 VSSO VSS dpnwcpl5 AREA=1.642e-11 PJ=2.45314e-05 nf=1
D76 VSSO VSS dpnwcpl5 AREA=1.642e-11 PJ=2.45314e-05 nf=1
D77 VSSO VSS dpnwcpl5 AREA=1.642e-11 PJ=2.45314e-05 nf=1
D78 VSSO VSS dpnwcpl5 AREA=1.642e-11 PJ=2.45314e-05 nf=1
D79 VSSO VSS dpnwcpl5 AREA=1.642e-11 PJ=2.45314e-05 nf=1
D80 VSSO VSS dpnwcpl5 AREA=1.642e-11 PJ=2.45314e-05 nf=1
D81 VSSO VSS dpnwcpl5 AREA=1.642e-11 PJ=2.45314e-05 nf=1
D82 VSSO VSS dpnwcpl5 AREA=1.642e-11 PJ=2.45314e-05 nf=1
D83 VSSO VSS dpnwcpl5 AREA=1.642e-11 PJ=2.45314e-05 nf=1
D84 VSS VSSO dpnwcpl5 AREA=1.642e-11 PJ=2.45314e-05 nf=1
D85 VSS VSSO dpnwcpl5 AREA=1.642e-11 PJ=2.45314e-05 nf=1
D86 VSS VSSO dpnwcpl5 AREA=1.642e-11 PJ=2.45314e-05 nf=1
D87 VSS VSSO dpnwcpl5 AREA=1.642e-11 PJ=2.45314e-05 nf=1
D88 VSS VSSO dpnwcpl5 AREA=1.642e-11 PJ=2.45314e-05 nf=1
D89 VSS VSSO dpnwcpl5 AREA=1.642e-11 PJ=2.45314e-05 nf=1
D90 VSS VSSO dpnwcpl5 AREA=1.642e-11 PJ=2.45314e-05 nf=1
D91 VSS VSSO dpnwcpl5 AREA=1.642e-11 PJ=2.45314e-05 nf=1
D92 VSS VSSO dpnwcpl5 AREA=1.642e-11 PJ=2.45314e-05 nf=1
.ENDS

.SUBCKT PVPP_50_NA PAD VDDO VSSO VSS VDD PADR
*.PININFO PAD:B VDDO:B VSSO:B VSS:B VDD:B PADR:B
M0 10 6 VSSO VSSO N5 L=6e-07 W=2e-05 rf_flag=0
M1 PADR 7 10 VSSO N5 L=6e-07 W=2e-05 rf_flag=0
R2 PAD 8 304.575 L=1e-06 W=2e-06 postlayout=1 $SUB=VDDO $[RE3]
R3 8 PADR 304.575 L=1e-06 W=2e-06 postlayout=1 $SUB=VDDO $[RE3]
R4 VSSO 6 1003.8 L=4.4e-06 W=2e-06 postlayout=1 $SUB=VSSO $[RE3]
R5 7 VDDO 1003.8 L=4.4e-06 W=2e-06 postlayout=1 $SUB=VSSO $[RE3]
D6 VSS VDDO dwn2psub AREA=6.35306e-10 PJ=0.00055146
D7 VSSO VDDO dwn2psub AREA=6.35306e-10 PJ=0.00055146
M8 11 VSSO VSSO VSSO n59pcesd L=6e-07 W=4.8e-05
M9 PAD 7 11 VSSO n59pcesd L=6e-07 W=4.8e-05
M10 12 7 PAD VSSO n59pcesd L=6e-07 W=4.8e-05
M11 VSSO VSSO 12 VSSO n59pcesd L=6e-07 W=4.8e-05
M12 13 VSSO VSSO VSSO n59pcesd L=6e-07 W=4.8e-05
M13 PAD 7 13 VSSO n59pcesd L=6e-07 W=4.8e-05
M14 14 7 PAD VSSO n59pcesd L=6e-07 W=4.8e-05
M15 VSSO VSSO 14 VSSO n59pcesd L=6e-07 W=4.8e-05
M16 15 VSSO VSSO VSSO n59pcesd L=6e-07 W=4.8e-05
M17 PAD 7 15 VSSO n59pcesd L=6e-07 W=4.8e-05
M18 16 7 PAD VSSO n59pcesd L=6e-07 W=4.8e-05
M19 VSSO VSSO 16 VSSO n59pcesd L=6e-07 W=4.8e-05
M20 17 VSSO VSSO VSSO n59pcesd L=6e-07 W=4.8e-05
M21 PAD 7 17 VSSO n59pcesd L=6e-07 W=4.8e-05
M22 18 7 PAD VSSO n59pcesd L=6e-07 W=4.8e-05
M23 VSSO VSSO 18 VSSO n59pcesd L=6e-07 W=4.8e-05
M24 19 VSSO VSSO VSSO n59pcesd L=6e-07 W=4.8e-05
M25 PAD 7 19 VSSO n59pcesd L=6e-07 W=4.8e-05
M26 20 7 PAD VSSO n59pcesd L=6e-07 W=4.8e-05
M27 VSSO VSSO 20 VSSO n59pcesd L=6e-07 W=4.8e-05
.ENDS

.SUBCKT PD0A_18_NA VSSO VDDO VSS VDD AVSSO
*.PININFO VSSO:B VDDO:B VSS:B VDD:B AVSSO:B
D0 VSS VDDO dwn2psub AREA=4.957e-10 PJ=0.0004917
D1 AVSSO VDDO dwn2psub AREA=4.957e-10 PJ=0.0004917
D2 VSSO VDDO dwn2psub AREA=4.957e-10 PJ=0.0004917
D3 AVSSO AVSSO dwn2psub AREA=6.3709e-10 PJ=0.00010544
D4 VSSO VSSO dwn2psub AREA=6.3709e-10 PJ=0.00010544
D5 VSSO AVSSO dpnwcpl18 AREA=2.242e-11 PJ=3.25314e-05 nf=1
D6 VSSO AVSSO dpnwcpl18 AREA=2.242e-11 PJ=3.25314e-05 nf=1
D7 VSSO AVSSO dpnwcpl18 AREA=2.242e-11 PJ=3.25314e-05 nf=1
D8 VSSO AVSSO dpnwcpl18 AREA=2.242e-11 PJ=3.25314e-05 nf=1
D9 VSSO AVSSO dpnwcpl18 AREA=2.242e-11 PJ=3.25314e-05 nf=1
D10 VSSO AVSSO dpnwcpl18 AREA=2.242e-11 PJ=3.25314e-05 nf=1
D11 VSSO AVSSO dpnwcpl18 AREA=2.242e-11 PJ=3.25314e-05 nf=1
D12 AVSSO VSSO dpnwcpl18 AREA=2.242e-11 PJ=3.25314e-05 nf=1
D13 AVSSO VSSO dpnwcpl18 AREA=2.242e-11 PJ=3.25314e-05 nf=1
D14 AVSSO VSSO dpnwcpl18 AREA=2.242e-11 PJ=3.25314e-05 nf=1
D15 AVSSO VSSO dpnwcpl18 AREA=2.242e-11 PJ=3.25314e-05 nf=1
D16 AVSSO VSSO dpnwcpl18 AREA=2.242e-11 PJ=3.25314e-05 nf=1
D17 AVSSO VSSO dpnwcpl18 AREA=2.242e-11 PJ=3.25314e-05 nf=1
D18 AVSSO VSSO dpnwcpl18 AREA=2.242e-11 PJ=3.25314e-05 nf=1
.ENDS

.SUBCKT PD0I_NA_18 VSS VDDO VDD VSSO AVSS
*.PININFO VSS:B VDDO:B VDD:B VSSO:B AVSS:B
D0 VSS VDD dwn2psub AREA=4.957e-10 PJ=0.0004917
D1 AVSS VDD dwn2psub AREA=4.957e-10 PJ=0.0004917
D2 VSS VDD dwn2psub AREA=4.957e-10 PJ=0.0004917
D3 AVSS AVSS dwn2psub AREA=6.3709e-10 PJ=0.00010544
D4 VSS VSS dwn2psub AREA=6.3709e-10 PJ=0.00010544
D5 VSS AVSS dpnwcpl18 AREA=2.242e-11 PJ=3.25314e-05 nf=1
D6 VSS AVSS dpnwcpl18 AREA=2.242e-11 PJ=3.25314e-05 nf=1
D7 VSS AVSS dpnwcpl18 AREA=2.242e-11 PJ=3.25314e-05 nf=1
D8 VSS AVSS dpnwcpl18 AREA=2.242e-11 PJ=3.25314e-05 nf=1
D9 VSS AVSS dpnwcpl18 AREA=2.242e-11 PJ=3.25314e-05 nf=1
D10 VSS AVSS dpnwcpl18 AREA=2.242e-11 PJ=3.25314e-05 nf=1
D11 VSS AVSS dpnwcpl18 AREA=2.242e-11 PJ=3.25314e-05 nf=1
D12 AVSS VSS dpnwcpl18 AREA=2.242e-11 PJ=3.25314e-05 nf=1
D13 AVSS VSS dpnwcpl18 AREA=2.242e-11 PJ=3.25314e-05 nf=1
D14 AVSS VSS dpnwcpl18 AREA=2.242e-11 PJ=3.25314e-05 nf=1
D15 AVSS VSS dpnwcpl18 AREA=2.242e-11 PJ=3.25314e-05 nf=1
D16 AVSS VSS dpnwcpl18 AREA=2.242e-11 PJ=3.25314e-05 nf=1
D17 AVSS VSS dpnwcpl18 AREA=2.242e-11 PJ=3.25314e-05 nf=1
D18 AVSS VSS dpnwcpl18 AREA=2.242e-11 PJ=3.25314e-05 nf=1
.ENDS

.SUBCKT PDDA_18_NA VDDO VSSO VSS VDD AVDDO
*.PININFO VDDO:B VSSO:B VSS:B VDD:B AVDDO:B
D0 VSS VDDO dwn2psub AREA=4.957e-10 PJ=0.0004917
D1 VSSO VDDO dwn2psub AREA=4.957e-10 PJ=0.0004917
D2 VSSO VDDO dwn2psub AREA=4.957e-10 PJ=0.0004917
D3 VSSO AVDDO dwn2psub AREA=6.3709e-10 PJ=0.00010544
D4 VSSO VDDO dwn2psub AREA=6.3709e-10 PJ=0.00010544
D5 VDDO AVDDO dpnwcpl18 AREA=2.242e-11 PJ=3.25314e-05 nf=1
D6 VDDO AVDDO dpnwcpl18 AREA=2.242e-11 PJ=3.25314e-05 nf=1
D7 VDDO AVDDO dpnwcpl18 AREA=2.242e-11 PJ=3.25314e-05 nf=1
D8 VDDO AVDDO dpnwcpl18 AREA=2.242e-11 PJ=3.25314e-05 nf=1
D9 VDDO AVDDO dpnwcpl18 AREA=2.242e-11 PJ=3.25314e-05 nf=1
D10 VDDO AVDDO dpnwcpl18 AREA=2.242e-11 PJ=3.25314e-05 nf=1
D11 VDDO AVDDO dpnwcpl18 AREA=2.242e-11 PJ=3.25314e-05 nf=1
D12 AVDDO VDDO dpnwcpl18 AREA=2.242e-11 PJ=3.25314e-05 nf=1
D13 AVDDO VDDO dpnwcpl18 AREA=2.242e-11 PJ=3.25314e-05 nf=1
D14 AVDDO VDDO dpnwcpl18 AREA=2.242e-11 PJ=3.25314e-05 nf=1
D15 AVDDO VDDO dpnwcpl18 AREA=2.242e-11 PJ=3.25314e-05 nf=1
D16 AVDDO VDDO dpnwcpl18 AREA=2.242e-11 PJ=3.25314e-05 nf=1
D17 AVDDO VDDO dpnwcpl18 AREA=2.242e-11 PJ=3.25314e-05 nf=1
D18 AVDDO VDDO dpnwcpl18 AREA=2.242e-11 PJ=3.25314e-05 nf=1
.ENDS

.SUBCKT PDDI_NA_18 VDD VSS VSSO AVDD VDDO
*.PININFO VDD:B VSS:B VSSO:B AVDD:B VDDO:B
D0 VSS VDD dwn2psub AREA=4.957e-10 PJ=0.0004917
D1 VSS VDD dwn2psub AREA=4.957e-10 PJ=0.0004917
D2 VSS VDD dwn2psub AREA=4.957e-10 PJ=0.0004917
D3 VSS AVDD dwn2psub AREA=6.3709e-10 PJ=0.00010544
D4 VSS VDD dwn2psub AREA=6.3709e-10 PJ=0.00010544
D5 VDD AVDD dpnwcpl18 AREA=2.242e-11 PJ=3.25314e-05 nf=1
D6 VDD AVDD dpnwcpl18 AREA=2.242e-11 PJ=3.25314e-05 nf=1
D7 VDD AVDD dpnwcpl18 AREA=2.242e-11 PJ=3.25314e-05 nf=1
D8 VDD AVDD dpnwcpl18 AREA=2.242e-11 PJ=3.25314e-05 nf=1
D9 VDD AVDD dpnwcpl18 AREA=2.242e-11 PJ=3.25314e-05 nf=1
D10 VDD AVDD dpnwcpl18 AREA=2.242e-11 PJ=3.25314e-05 nf=1
D11 VDD AVDD dpnwcpl18 AREA=2.242e-11 PJ=3.25314e-05 nf=1
D12 AVDD VDD dpnwcpl18 AREA=2.242e-11 PJ=3.25314e-05 nf=1
D13 AVDD VDD dpnwcpl18 AREA=2.242e-11 PJ=3.25314e-05 nf=1
D14 AVDD VDD dpnwcpl18 AREA=2.242e-11 PJ=3.25314e-05 nf=1
D15 AVDD VDD dpnwcpl18 AREA=2.242e-11 PJ=3.25314e-05 nf=1
D16 AVDD VDD dpnwcpl18 AREA=2.242e-11 PJ=3.25314e-05 nf=1
D17 AVDD VDD dpnwcpl18 AREA=2.242e-11 PJ=3.25314e-05 nf=1
D18 AVDD VDD dpnwcpl18 AREA=2.242e-11 PJ=3.25314e-05 nf=1
.ENDS

.SUBCKT PD0A_50_NA VSSO VDDO VSS VDD AVSSO
*.PININFO VSSO:B VDDO:B VSS:B VDD:B AVSSO:B
D0 VSS VDDO dwn2psub AREA=4.957e-10 PJ=0.0004917
D1 AVSSO VDDO dwn2psub AREA=4.957e-10 PJ=0.0004917
D2 VSSO VDDO dwn2psub AREA=4.957e-10 PJ=0.0004917
D3 AVSSO AVSSO dwn2psub AREA=6.3709e-10 PJ=0.00010544
D4 VSSO VSSO dwn2psub AREA=6.3709e-10 PJ=0.00010544
D5 VSSO AVSSO dpnwcpl5 AREA=2.242e-11 PJ=3.25314e-05 nf=1
D6 VSSO AVSSO dpnwcpl5 AREA=2.242e-11 PJ=3.25314e-05 nf=1
D7 VSSO AVSSO dpnwcpl5 AREA=2.242e-11 PJ=3.25314e-05 nf=1
D8 VSSO AVSSO dpnwcpl5 AREA=2.242e-11 PJ=3.25314e-05 nf=1
D9 VSSO AVSSO dpnwcpl5 AREA=2.242e-11 PJ=3.25314e-05 nf=1
D10 VSSO AVSSO dpnwcpl5 AREA=2.242e-11 PJ=3.25314e-05 nf=1
D11 VSSO AVSSO dpnwcpl5 AREA=2.242e-11 PJ=3.25314e-05 nf=1
D12 AVSSO VSSO dpnwcpl5 AREA=2.242e-11 PJ=3.25314e-05 nf=1
D13 AVSSO VSSO dpnwcpl5 AREA=2.242e-11 PJ=3.25314e-05 nf=1
D14 AVSSO VSSO dpnwcpl5 AREA=2.242e-11 PJ=3.25314e-05 nf=1
D15 AVSSO VSSO dpnwcpl5 AREA=2.242e-11 PJ=3.25314e-05 nf=1
D16 AVSSO VSSO dpnwcpl5 AREA=2.242e-11 PJ=3.25314e-05 nf=1
D17 AVSSO VSSO dpnwcpl5 AREA=2.242e-11 PJ=3.25314e-05 nf=1
D18 AVSSO VSSO dpnwcpl5 AREA=2.242e-11 PJ=3.25314e-05 nf=1
.ENDS

.SUBCKT PD0I_NA_50 VSS VDDO VDD VSSO AVSS
*.PININFO VSS:B VDDO:B VDD:B VSSO:B AVSS:B
D0 VSS VDD dwn2psub AREA=4.957e-10 PJ=0.0004917
D1 AVSS VDD dwn2psub AREA=4.957e-10 PJ=0.0004917
D2 VSS VDD dwn2psub AREA=4.957e-10 PJ=0.0004917
D3 AVSS AVSS dwn2psub AREA=6.3709e-10 PJ=0.00010544
D4 VSS VSS dwn2psub AREA=6.3709e-10 PJ=0.00010544
D5 VSS AVSS dpnwcpl5 AREA=2.242e-11 PJ=3.25314e-05 nf=1
D6 VSS AVSS dpnwcpl5 AREA=2.242e-11 PJ=3.25314e-05 nf=1
D7 VSS AVSS dpnwcpl5 AREA=2.242e-11 PJ=3.25314e-05 nf=1
D8 VSS AVSS dpnwcpl5 AREA=2.242e-11 PJ=3.25314e-05 nf=1
D9 VSS AVSS dpnwcpl5 AREA=2.242e-11 PJ=3.25314e-05 nf=1
D10 VSS AVSS dpnwcpl5 AREA=2.242e-11 PJ=3.25314e-05 nf=1
D11 VSS AVSS dpnwcpl5 AREA=2.242e-11 PJ=3.25314e-05 nf=1
D12 AVSS VSS dpnwcpl5 AREA=2.242e-11 PJ=3.25314e-05 nf=1
D13 AVSS VSS dpnwcpl5 AREA=2.242e-11 PJ=3.25314e-05 nf=1
D14 AVSS VSS dpnwcpl5 AREA=2.242e-11 PJ=3.25314e-05 nf=1
D15 AVSS VSS dpnwcpl5 AREA=2.242e-11 PJ=3.25314e-05 nf=1
D16 AVSS VSS dpnwcpl5 AREA=2.242e-11 PJ=3.25314e-05 nf=1
D17 AVSS VSS dpnwcpl5 AREA=2.242e-11 PJ=3.25314e-05 nf=1
D18 AVSS VSS dpnwcpl5 AREA=2.242e-11 PJ=3.25314e-05 nf=1
.ENDS

.SUBCKT PDDA_50_NA VDDO VSSO VSS VDD AVDDO
*.PININFO VDDO:B VSSO:B VSS:B VDD:B AVDDO:B
D0 VSS VDDO dwn2psub AREA=4.957e-10 PJ=0.0004917
D1 VSSO VDDO dwn2psub AREA=4.957e-10 PJ=0.0004917
D2 VSSO VDDO dwn2psub AREA=4.957e-10 PJ=0.0004917
D3 VSSO AVDDO dwn2psub AREA=6.3709e-10 PJ=0.00010544
D4 VSSO VDDO dwn2psub AREA=6.3709e-10 PJ=0.00010544
D5 VDDO AVDDO dpnwcpl5 AREA=2.242e-11 PJ=3.25314e-05 nf=1
D6 VDDO AVDDO dpnwcpl5 AREA=2.242e-11 PJ=3.25314e-05 nf=1
D7 VDDO AVDDO dpnwcpl5 AREA=2.242e-11 PJ=3.25314e-05 nf=1
D8 VDDO AVDDO dpnwcpl5 AREA=2.242e-11 PJ=3.25314e-05 nf=1
D9 VDDO AVDDO dpnwcpl5 AREA=2.242e-11 PJ=3.25314e-05 nf=1
D10 VDDO AVDDO dpnwcpl5 AREA=2.242e-11 PJ=3.25314e-05 nf=1
D11 VDDO AVDDO dpnwcpl5 AREA=2.242e-11 PJ=3.25314e-05 nf=1
D12 AVDDO VDDO dpnwcpl5 AREA=2.242e-11 PJ=3.25314e-05 nf=1
D13 AVDDO VDDO dpnwcpl5 AREA=2.242e-11 PJ=3.25314e-05 nf=1
D14 AVDDO VDDO dpnwcpl5 AREA=2.242e-11 PJ=3.25314e-05 nf=1
D15 AVDDO VDDO dpnwcpl5 AREA=2.242e-11 PJ=3.25314e-05 nf=1
D16 AVDDO VDDO dpnwcpl5 AREA=2.242e-11 PJ=3.25314e-05 nf=1
D17 AVDDO VDDO dpnwcpl5 AREA=2.242e-11 PJ=3.25314e-05 nf=1
D18 AVDDO VDDO dpnwcpl5 AREA=2.242e-11 PJ=3.25314e-05 nf=1
.ENDS

.SUBCKT PDDI_NA_50 VDD VSS VSSO AVDD VDDO
*.PININFO VDD:B VSS:B VSSO:B AVDD:B VDDO:B
D0 VSS VDD dwn2psub AREA=4.957e-10 PJ=0.0004917
D1 VSS VDD dwn2psub AREA=4.957e-10 PJ=0.0004917
D2 VSS VDD dwn2psub AREA=4.957e-10 PJ=0.0004917
D3 VSS AVDD dwn2psub AREA=6.3709e-10 PJ=0.00010544
D4 VSS VDD dwn2psub AREA=6.3709e-10 PJ=0.00010544
D5 VDD AVDD dpnwcpl5 AREA=2.242e-11 PJ=3.25314e-05 nf=1
D6 VDD AVDD dpnwcpl5 AREA=2.242e-11 PJ=3.25314e-05 nf=1
D7 VDD AVDD dpnwcpl5 AREA=2.242e-11 PJ=3.25314e-05 nf=1
D8 VDD AVDD dpnwcpl5 AREA=2.242e-11 PJ=3.25314e-05 nf=1
D9 VDD AVDD dpnwcpl5 AREA=2.242e-11 PJ=3.25314e-05 nf=1
D10 VDD AVDD dpnwcpl5 AREA=2.242e-11 PJ=3.25314e-05 nf=1
D11 VDD AVDD dpnwcpl5 AREA=2.242e-11 PJ=3.25314e-05 nf=1
D12 AVDD VDD dpnwcpl5 AREA=2.242e-11 PJ=3.25314e-05 nf=1
D13 AVDD VDD dpnwcpl5 AREA=2.242e-11 PJ=3.25314e-05 nf=1
D14 AVDD VDD dpnwcpl5 AREA=2.242e-11 PJ=3.25314e-05 nf=1
D15 AVDD VDD dpnwcpl5 AREA=2.242e-11 PJ=3.25314e-05 nf=1
D16 AVDD VDD dpnwcpl5 AREA=2.242e-11 PJ=3.25314e-05 nf=1
D17 AVDD VDD dpnwcpl5 AREA=2.242e-11 PJ=3.25314e-05 nf=1
D18 AVDD VDD dpnwcpl5 AREA=2.242e-11 PJ=3.25314e-05 nf=1
.ENDS

.SUBCKT PFILL0010_NA_NA VDDO VSSO VSS VDD
*.PININFO VDDO:B VSSO:B VSS:B VDD:B
.ENDS

.SUBCKT PFILL0001_NA_NA VDDO VSSO VSS VDD
*.PININFO VDDO:B VSSO:B VSS:B VDD:B
.ENDS

.SUBCKT PCORNER_NA_NA VDDO VSSO VSS VDD
*.PININFO VDDO:B VSSO:B VSS:B VDD:B
.ENDS

.SUBCKT PRENROC_NA_NA VDDO VSSO VSS VDD
*.PININFO VDDO:B VSSO:B VSS:B VDD:B
.ENDS

.SUBCKT PC0A_18_NA VDDO AVSSO VSSO VSS VDD
*.PININFO VDDO:B AVSSO:B VSSO:B VSS:B VDD:B
.ENDS

.SUBCKT PCDA_18_NA AVDDO VDDO VSSO VSS VDD
*.PININFO AVDDO:B VDDO:B VSSO:B VSS:B VDD:B
.ENDS

.SUBCKT PCDI_NA_18 VDDO VSSO VSS AVDD VDD
*.PININFO VDDO:B VSSO:B VSS:B AVDD:B VDD:B
.ENDS

.SUBCKT PC0I_NA_18 VDDO VSSO AVSS VSS VDD
*.PININFO VDDO:B VSSO:B AVSS:B VSS:B VDD:B
.ENDS

.SUBCKT PC0A_50_NA VDDO AVSSO VSSO VSS VDD
*.PININFO VDDO:B AVSSO:B VSSO:B VSS:B VDD:B
.ENDS

.SUBCKT PCDA_50_NA AVDDO VDDO VSSO VSS VDD
*.PININFO AVDDO:B VDDO:B VSSO:B VSS:B VDD:B
.ENDS

.SUBCKT PCDI_NA_50 VDDO VSSO VSS AVDD VDD
*.PININFO VDDO:B VSSO:B VSS:B AVDD:B VDD:B
.ENDS

.SUBCKT PC0I_NA_50 VDDO VSSO AVSS VSS VDD
*.PININFO VDDO:B VSSO:B AVSS:B VSS:B VDD:B
.ENDS

.option scale = 1e-6
